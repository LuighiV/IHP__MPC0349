** sch_path: /foss/designs/Design/UNICASS/unic-cass-analog-team3/designs/libs/IHP__MPC0349/MPC0349-main/schematic/xschem/MPC0349.sch
**.subckt MPC0349
x1 VDD3 VSS3 analog_io[0] net5 analog_io[1] analog_io_padres[19] ui_PAD[2] analog_io[20_21] analog_io[20_21] ui_PAD[3]
+ analog_io_padres[22] analog_io[4] analog_io[5] analog_io[24_23] analog_io[6] analog_io[24_23] analog_io_padres[25] analog_io[7] net4 uo_PAD[8]
+ analog_io[27] net6 net7 analog_io[28] net8 analog_io[29] net9 analog_io[30] ui_PAD[31] net10 analog_io[32] net11 net12 analog_io[33] net13
+ analog_io[34] net14 analog_io[35] net3 net2 VDD1 VSS1 IOVDD1 IOVSS1 IOVDD4 IOVSS4 VDD4 VSS4 analog_io_padres[28] analog_io_padres[29]
+ analog_io_padres[33] analog_io_padres[34] ui_P2C[31] uo_c2p[8] analog_io_padres[6] analog_io_padres[0] analog_io_padres[1] ui_p2c[2] uo_c2p[3]
+ analog_io_padres[5] ui_p2c[9] user_project_wrapper
x2 VDD1 analog_io_padres[5] analog_io[7] analog_io[4] analog_io_padres[0] ui_p2c[9] uo_c2p[8] analog_io_padres[6] VSS1 555
x3 VDD3 analog_io_padres[22] analog_io[20_21] analog_io[24_23] analog_io_padres[19] analog_io_padres[25] VSS3 HPA
x4 VDD4 analog_io_padres[34] ui_P2C[31] analog_io[32] net1 analog_io_padres[33] analog_io[35] analog_io_padres[29]
+ analog_io_padres[28] analog_io[27] analog_io[30] TOP_ROILIFNEURON
x6 net15 net16 net17 net18 net19 net20 net21 net22 net23 net24 QDLL_TOP
x5 VDD1 analog_io_padres[1] analog_io_padres[0] uo_c2p[3] ui_p2c[2] VSS1 PWMADCSYM
* noconn #net4
* noconn #net3
* noconn #net2
* noconn #net5
**.ends

* expanding   symbol:  IHP__MPC0349/MPC0349-main/schematic/xschem/user_project_wrapper.sym # of pins=65
** sym_path: /foss/designs/Design/UNICASS/unic-cass-analog-team3/designs/libs/IHP__MPC0349/MPC0349-main/schematic/xschem/user_project_wrapper.sym
** sch_path: /foss/designs/Design/UNICASS/unic-cass-analog-team3/designs/libs/IHP__MPC0349/MPC0349-main/schematic/xschem/user_project_wrapper.sch
.subckt user_project_wrapper VDD3 VSS3 analog_io[0] analog_io[18] analog_io[1] analog_io[19] ui_PAD[2] analog_io[20] analog_io[21]
+ uo_PAD[3] analog_io_padres[22] analog_io[4] analog_io[5] analog_io[23] analog_io[6] analog_io[24] analog_io[25] analog_io[7] analog_io[26]
+ uo_PAD[8] analog_io[27] ui_PAD[9] analog_io[10] analog_io[28] analog_io[11] analog_io[29] analog_io[12] analog_io[30] ui_PAD[31]
+ analog_io[13] analog_io[32] analog_io[14] analog_io[15] analog_io[33] analog_io[16] analog_io[34] analog_io[17] analog_io[35] IOVDD3 IOVSS3
+ VDD1 VSS1 IOVDD1 IOVSS1 IOVDD IOVSS VDD VSS analog_io_padres[28] analog_io_padres[29] analog_io_padres[33] analog_io_padres[34]
+ ui_p2c[31] uo_c2p[8] analog_io_padres[6] analog_io_padres[0] analog_io_padres[1] ui_p2c[2] uo_c2p[3] analog_io_padres[5] ui_p2c[9]
*.iopin VSS1
*.iopin VDD1
*.iopin IOVDD1
*.iopin IOVSS1
*.iopin analog_io[35],analog_io[34],analog_io[33],analog_io[32]
*.iopin
*+ analog_io[30],analog_io[29],analog_io[28],analog_io[27],analog_io[26],analog_io[25],analog_io[24],analog_io[23],analog_io[22],analog_io[21],analog_io[20],analog_io[19],analog_io[18],analog_io[17],analog_io[16],analog_io[15],analog_io[14],analog_io[13],analog_io[12],analog_io[11],analog_io[10]
*.iopin analog_io[7],analog_io[6],analog_io[5],analog_io[4]
*.iopin analog_io[1],analog_io[0]
*.iopin ui_PAD[31]
*.iopin ui_PAD[9]
*.iopin uo_PAD[8]
*.iopin uo_PAD[3]
*.iopin ui_PAD[2]
*.iopin VSS2
*.iopin VDD2
*.iopin IOVDD2
*.iopin IOVSS2
*.iopin VSS3
*.iopin VDD3
*.iopin IOVDD3
*.iopin IOVSS3
*.iopin VSS4
*.iopin VDD4
*.iopin IOVDD4
*.iopin IOVSS4
*.iopin analog_io_padres[29],analog_io_padres[28]
*.iopin analog_io_padres[34],analog_io_padres[33]
*.iopin ui_p2c[31]
*.iopin ui_p2c[9]
*.iopin ui_p2c[2]
*.iopin analog_io_padres[5],analog_io_padres[6]
*.iopin analog_io_padres[0],analog_io_padres[1]
*.iopin uo_c2p[8]
*.iopin uo_c2p[3]
x5 IOVDD1 VDD1 VSS1 SUB IOVSS1 IOVSS1 IOVSS1 sg13g2_Corner_noptap
x6 VSS1 VDD1 SUB IOVSS1 IOVDD1 IOVSS1 ui_PAD[9] ui_p2c[9] sg13g2_IOPadIn
x10 VSS2 VDD2 SUB IOVSS2 IOVDD2 IOVSS2 sg13g2_IOPadVss
x11[7] IOVDD IOVSS VDD IOVSS IOVSS VSS SUB sg13g2_Filler4000
x11[6] IOVDD IOVSS VDD IOVSS IOVSS VSS SUB sg13g2_Filler4000
x11[5] IOVDD IOVSS VDD IOVSS IOVSS VSS SUB sg13g2_Filler4000
x11[4] IOVDD IOVSS VDD IOVSS IOVSS VSS SUB sg13g2_Filler4000
x11[3] IOVDD IOVSS VDD IOVSS IOVSS VSS SUB sg13g2_Filler4000
x11[2] IOVDD IOVSS VDD IOVSS IOVSS VSS SUB sg13g2_Filler4000
x11[1] IOVDD IOVSS VDD IOVSS IOVSS VSS SUB sg13g2_Filler4000
x11[0] IOVDD IOVSS VDD IOVSS IOVSS VSS SUB sg13g2_Filler4000
x12[7] IOVDD IOVSS VDD IOVSS IOVSS VSS SUB sg13g2_Filler1000
x12[6] IOVDD IOVSS VDD IOVSS IOVSS VSS SUB sg13g2_Filler1000
x12[5] IOVDD IOVSS VDD IOVSS IOVSS VSS SUB sg13g2_Filler1000
x12[4] IOVDD IOVSS VDD IOVSS IOVSS VSS SUB sg13g2_Filler1000
x12[3] IOVDD IOVSS VDD IOVSS IOVSS VSS SUB sg13g2_Filler1000
x12[2] IOVDD IOVSS VDD IOVSS IOVSS VSS SUB sg13g2_Filler1000
x12[1] IOVDD IOVSS VDD IOVSS IOVSS VSS SUB sg13g2_Filler1000
x12[0] IOVDD IOVSS VDD IOVSS IOVSS VSS SUB sg13g2_Filler1000
x13[7] IOVDD IOVSS VDD IOVSS IOVSS VSS SUB sg13g2_Filler400
x13[6] IOVDD IOVSS VDD IOVSS IOVSS VSS SUB sg13g2_Filler400
x13[5] IOVDD IOVSS VDD IOVSS IOVSS VSS SUB sg13g2_Filler400
x13[4] IOVDD IOVSS VDD IOVSS IOVSS VSS SUB sg13g2_Filler400
x13[3] IOVDD IOVSS VDD IOVSS IOVSS VSS SUB sg13g2_Filler400
x13[2] IOVDD IOVSS VDD IOVSS IOVSS VSS SUB sg13g2_Filler400
x13[1] IOVDD IOVSS VDD IOVSS IOVSS VSS SUB sg13g2_Filler400
x13[0] IOVDD IOVSS VDD IOVSS IOVSS VSS SUB sg13g2_Filler400
x14[7] IOVDD IOVSS VDD IOVSS IOVSS VSS SUB sg13g2_Filler200
x14[6] IOVDD IOVSS VDD IOVSS IOVSS VSS SUB sg13g2_Filler200
x14[5] IOVDD IOVSS VDD IOVSS IOVSS VSS SUB sg13g2_Filler200
x14[4] IOVDD IOVSS VDD IOVSS IOVSS VSS SUB sg13g2_Filler200
x14[3] IOVDD IOVSS VDD IOVSS IOVSS VSS SUB sg13g2_Filler200
x14[2] IOVDD IOVSS VDD IOVSS IOVSS VSS SUB sg13g2_Filler200
x14[1] IOVDD IOVSS VDD IOVSS IOVSS VSS SUB sg13g2_Filler200
x14[0] IOVDD IOVSS VDD IOVSS IOVSS VSS SUB sg13g2_Filler200
x15 VSS2 VDD2 SUB IOVSS2 IOVDD2 IOVSS2 sg13g2_IOPadVdd
x16[47] IOVDD IOVSS VDD IOVSS IOVSS VSS SUB sg13g2_Filler4000
x16[46] IOVDD IOVSS VDD IOVSS IOVSS VSS SUB sg13g2_Filler4000
x16[45] IOVDD IOVSS VDD IOVSS IOVSS VSS SUB sg13g2_Filler4000
x16[44] IOVDD IOVSS VDD IOVSS IOVSS VSS SUB sg13g2_Filler4000
x16[43] IOVDD IOVSS VDD IOVSS IOVSS VSS SUB sg13g2_Filler4000
x16[42] IOVDD IOVSS VDD IOVSS IOVSS VSS SUB sg13g2_Filler4000
x16[41] IOVDD IOVSS VDD IOVSS IOVSS VSS SUB sg13g2_Filler4000
x16[40] IOVDD IOVSS VDD IOVSS IOVSS VSS SUB sg13g2_Filler4000
x16[39] IOVDD IOVSS VDD IOVSS IOVSS VSS SUB sg13g2_Filler4000
x16[38] IOVDD IOVSS VDD IOVSS IOVSS VSS SUB sg13g2_Filler4000
x16[37] IOVDD IOVSS VDD IOVSS IOVSS VSS SUB sg13g2_Filler4000
x16[36] IOVDD IOVSS VDD IOVSS IOVSS VSS SUB sg13g2_Filler4000
x16[35] IOVDD IOVSS VDD IOVSS IOVSS VSS SUB sg13g2_Filler4000
x16[34] IOVDD IOVSS VDD IOVSS IOVSS VSS SUB sg13g2_Filler4000
x16[33] IOVDD IOVSS VDD IOVSS IOVSS VSS SUB sg13g2_Filler4000
x16[32] IOVDD IOVSS VDD IOVSS IOVSS VSS SUB sg13g2_Filler4000
x16[31] IOVDD IOVSS VDD IOVSS IOVSS VSS SUB sg13g2_Filler4000
x16[30] IOVDD IOVSS VDD IOVSS IOVSS VSS SUB sg13g2_Filler4000
x16[29] IOVDD IOVSS VDD IOVSS IOVSS VSS SUB sg13g2_Filler4000
x16[28] IOVDD IOVSS VDD IOVSS IOVSS VSS SUB sg13g2_Filler4000
x16[27] IOVDD IOVSS VDD IOVSS IOVSS VSS SUB sg13g2_Filler4000
x16[26] IOVDD IOVSS VDD IOVSS IOVSS VSS SUB sg13g2_Filler4000
x16[25] IOVDD IOVSS VDD IOVSS IOVSS VSS SUB sg13g2_Filler4000
x16[24] IOVDD IOVSS VDD IOVSS IOVSS VSS SUB sg13g2_Filler4000
x16[23] IOVDD IOVSS VDD IOVSS IOVSS VSS SUB sg13g2_Filler4000
x16[22] IOVDD IOVSS VDD IOVSS IOVSS VSS SUB sg13g2_Filler4000
x16[21] IOVDD IOVSS VDD IOVSS IOVSS VSS SUB sg13g2_Filler4000
x16[20] IOVDD IOVSS VDD IOVSS IOVSS VSS SUB sg13g2_Filler4000
x16[19] IOVDD IOVSS VDD IOVSS IOVSS VSS SUB sg13g2_Filler4000
x16[18] IOVDD IOVSS VDD IOVSS IOVSS VSS SUB sg13g2_Filler4000
x16[17] IOVDD IOVSS VDD IOVSS IOVSS VSS SUB sg13g2_Filler4000
x16[16] IOVDD IOVSS VDD IOVSS IOVSS VSS SUB sg13g2_Filler4000
x16[15] IOVDD IOVSS VDD IOVSS IOVSS VSS SUB sg13g2_Filler4000
x16[14] IOVDD IOVSS VDD IOVSS IOVSS VSS SUB sg13g2_Filler4000
x16[13] IOVDD IOVSS VDD IOVSS IOVSS VSS SUB sg13g2_Filler4000
x16[12] IOVDD IOVSS VDD IOVSS IOVSS VSS SUB sg13g2_Filler4000
x16[11] IOVDD IOVSS VDD IOVSS IOVSS VSS SUB sg13g2_Filler4000
x16[10] IOVDD IOVSS VDD IOVSS IOVSS VSS SUB sg13g2_Filler4000
x16[9] IOVDD IOVSS VDD IOVSS IOVSS VSS SUB sg13g2_Filler4000
x16[8] IOVDD IOVSS VDD IOVSS IOVSS VSS SUB sg13g2_Filler4000
x16[7] IOVDD IOVSS VDD IOVSS IOVSS VSS SUB sg13g2_Filler4000
x16[6] IOVDD IOVSS VDD IOVSS IOVSS VSS SUB sg13g2_Filler4000
x16[5] IOVDD IOVSS VDD IOVSS IOVSS VSS SUB sg13g2_Filler4000
x16[4] IOVDD IOVSS VDD IOVSS IOVSS VSS SUB sg13g2_Filler4000
x16[3] IOVDD IOVSS VDD IOVSS IOVSS VSS SUB sg13g2_Filler4000
x16[2] IOVDD IOVSS VDD IOVSS IOVSS VSS SUB sg13g2_Filler4000
x16[1] IOVDD IOVSS VDD IOVSS IOVSS VSS SUB sg13g2_Filler4000
x16[0] IOVDD IOVSS VDD IOVSS IOVSS VSS SUB sg13g2_Filler4000
x17[47] IOVDD IOVSS VDD IOVSS IOVSS VSS SUB sg13g2_Filler400
x17[46] IOVDD IOVSS VDD IOVSS IOVSS VSS SUB sg13g2_Filler400
x17[45] IOVDD IOVSS VDD IOVSS IOVSS VSS SUB sg13g2_Filler400
x17[44] IOVDD IOVSS VDD IOVSS IOVSS VSS SUB sg13g2_Filler400
x17[43] IOVDD IOVSS VDD IOVSS IOVSS VSS SUB sg13g2_Filler400
x17[42] IOVDD IOVSS VDD IOVSS IOVSS VSS SUB sg13g2_Filler400
x17[41] IOVDD IOVSS VDD IOVSS IOVSS VSS SUB sg13g2_Filler400
x17[40] IOVDD IOVSS VDD IOVSS IOVSS VSS SUB sg13g2_Filler400
x17[39] IOVDD IOVSS VDD IOVSS IOVSS VSS SUB sg13g2_Filler400
x17[38] IOVDD IOVSS VDD IOVSS IOVSS VSS SUB sg13g2_Filler400
x17[37] IOVDD IOVSS VDD IOVSS IOVSS VSS SUB sg13g2_Filler400
x17[36] IOVDD IOVSS VDD IOVSS IOVSS VSS SUB sg13g2_Filler400
x17[35] IOVDD IOVSS VDD IOVSS IOVSS VSS SUB sg13g2_Filler400
x17[34] IOVDD IOVSS VDD IOVSS IOVSS VSS SUB sg13g2_Filler400
x17[33] IOVDD IOVSS VDD IOVSS IOVSS VSS SUB sg13g2_Filler400
x17[32] IOVDD IOVSS VDD IOVSS IOVSS VSS SUB sg13g2_Filler400
x17[31] IOVDD IOVSS VDD IOVSS IOVSS VSS SUB sg13g2_Filler400
x17[30] IOVDD IOVSS VDD IOVSS IOVSS VSS SUB sg13g2_Filler400
x17[29] IOVDD IOVSS VDD IOVSS IOVSS VSS SUB sg13g2_Filler400
x17[28] IOVDD IOVSS VDD IOVSS IOVSS VSS SUB sg13g2_Filler400
x17[27] IOVDD IOVSS VDD IOVSS IOVSS VSS SUB sg13g2_Filler400
x17[26] IOVDD IOVSS VDD IOVSS IOVSS VSS SUB sg13g2_Filler400
x17[25] IOVDD IOVSS VDD IOVSS IOVSS VSS SUB sg13g2_Filler400
x17[24] IOVDD IOVSS VDD IOVSS IOVSS VSS SUB sg13g2_Filler400
x17[23] IOVDD IOVSS VDD IOVSS IOVSS VSS SUB sg13g2_Filler400
x17[22] IOVDD IOVSS VDD IOVSS IOVSS VSS SUB sg13g2_Filler400
x17[21] IOVDD IOVSS VDD IOVSS IOVSS VSS SUB sg13g2_Filler400
x17[20] IOVDD IOVSS VDD IOVSS IOVSS VSS SUB sg13g2_Filler400
x17[19] IOVDD IOVSS VDD IOVSS IOVSS VSS SUB sg13g2_Filler400
x17[18] IOVDD IOVSS VDD IOVSS IOVSS VSS SUB sg13g2_Filler400
x17[17] IOVDD IOVSS VDD IOVSS IOVSS VSS SUB sg13g2_Filler400
x17[16] IOVDD IOVSS VDD IOVSS IOVSS VSS SUB sg13g2_Filler400
x17[15] IOVDD IOVSS VDD IOVSS IOVSS VSS SUB sg13g2_Filler400
x17[14] IOVDD IOVSS VDD IOVSS IOVSS VSS SUB sg13g2_Filler400
x17[13] IOVDD IOVSS VDD IOVSS IOVSS VSS SUB sg13g2_Filler400
x17[12] IOVDD IOVSS VDD IOVSS IOVSS VSS SUB sg13g2_Filler400
x17[11] IOVDD IOVSS VDD IOVSS IOVSS VSS SUB sg13g2_Filler400
x17[10] IOVDD IOVSS VDD IOVSS IOVSS VSS SUB sg13g2_Filler400
x17[9] IOVDD IOVSS VDD IOVSS IOVSS VSS SUB sg13g2_Filler400
x17[8] IOVDD IOVSS VDD IOVSS IOVSS VSS SUB sg13g2_Filler400
x17[7] IOVDD IOVSS VDD IOVSS IOVSS VSS SUB sg13g2_Filler400
x17[6] IOVDD IOVSS VDD IOVSS IOVSS VSS SUB sg13g2_Filler400
x17[5] IOVDD IOVSS VDD IOVSS IOVSS VSS SUB sg13g2_Filler400
x17[4] IOVDD IOVSS VDD IOVSS IOVSS VSS SUB sg13g2_Filler400
x17[3] IOVDD IOVSS VDD IOVSS IOVSS VSS SUB sg13g2_Filler400
x17[2] IOVDD IOVSS VDD IOVSS IOVSS VSS SUB sg13g2_Filler400
x17[1] IOVDD IOVSS VDD IOVSS IOVSS VSS SUB sg13g2_Filler400
x17[0] IOVDD IOVSS VDD IOVSS IOVSS VSS SUB sg13g2_Filler400
x1 IOVDD2 VSS2 analog_io[10] VDD2 SUB net1 IOVSS2 IOVDD2 sg13g2_IOPadAnalog
x2 IOVDD2 VSS2 analog_io[11] VDD2 SUB net2 IOVSS2 IOVDD2 sg13g2_IOPadAnalog
x3 IOVDD2 VSS2 analog_io[12] VDD2 SUB net3 IOVSS2 IOVDD2 sg13g2_IOPadAnalog
x4 IOVDD2 VSS2 analog_io[13] VDD2 SUB net4 IOVSS2 IOVDD2 sg13g2_IOPadAnalog
x11 IOVDD2 VSS2 analog_io[14] VDD2 SUB net5 IOVSS2 IOVDD2 sg13g2_IOPadAnalog
x12 IOVDD2 VSS2 analog_io[15] VDD2 SUB net6 IOVSS2 IOVDD2 sg13g2_IOPadAnalog
x13 IOVDD2 VSS2 analog_io[16] VDD2 SUB net7 IOVSS2 IOVDD2 sg13g2_IOPadAnalog
x14 IOVDD2 VSS2 analog_io[17] VDD2 SUB net8 IOVSS2 IOVDD2 sg13g2_IOPadAnalog
x16 VSS2 VDD2 SUB IOVSS2 IOVDD2 IOVSS2 sg13g2_IOPadIOVdd
x17 VSS2 VDD2 SUB IOVSS2 IOVDD2 sg13g2_IOPadIOVss
* noconn #net1
* noconn #net2
* noconn #net3
* noconn #net4
* noconn #net5
* noconn #net6
* noconn #net7
* noconn #net8
x7 IOVDD2 VDD2 VSS2 SUB IOVSS2 IOVSS2 IOVSS2 sg13g2_Corner_noptap
x8 IOVDD3 VSS3 analog_io[18] VDD3 SUB net9 IOVSS3 IOVDD3 sg13g2_IOPadAnalog
x9 VSS3 VDD3 SUB IOVSS3 IOVDD3 IOVSS3 sg13g2_IOPadVss
x18 VSS3 VDD3 SUB IOVSS3 IOVDD3 IOVSS3 sg13g2_IOPadVdd
x19 IOVDD3 VSS3 analog_io[19] VDD3 SUB net10 IOVSS3 IOVDD3 sg13g2_IOPadAnalog
x20 IOVDD3 VSS3 analog_io[20] VDD3 SUB net11 IOVSS3 IOVDD3 sg13g2_IOPadAnalog
x21 IOVDD3 VSS3 analog_io[21] VDD3 SUB net12 IOVSS3 IOVDD3 sg13g2_IOPadAnalog
x22 IOVDD3 VSS3 analog_io[22] VDD3 SUB net13 IOVSS3 IOVDD3 sg13g2_IOPadAnalog
x23 IOVDD3 VSS3 analog_io[23] VDD3 SUB net14 IOVSS3 IOVDD3 sg13g2_IOPadAnalog
x24 IOVDD3 VSS3 analog_io[24] VDD3 SUB net15 IOVSS3 IOVDD3 sg13g2_IOPadAnalog
x25 IOVDD3 VSS3 analog_io[25] VDD3 SUB net16 IOVSS3 IOVDD3 sg13g2_IOPadAnalog
x26 IOVDD3 VSS3 analog_io[26] VDD3 SUB net17 IOVSS3 IOVDD3 sg13g2_IOPadAnalog
x27 VSS3 VDD3 SUB IOVSS3 IOVDD3 IOVSS3 sg13g2_IOPadIOVdd
x28 VSS3 VDD3 SUB IOVSS3 IOVDD3 sg13g2_IOPadIOVss
* noconn #net9
* noconn #net10
* noconn #net11
* noconn #net12
* noconn #net13
* noconn #net14
* noconn #net15
* noconn #net16
* noconn #net17
* noconn SUB
x29 IOVDD3 VDD3 VSS3 SUB IOVSS3 IOVSS3 IOVSS3 sg13g2_Corner_noptap
x30 IOVDD4 VSS4 analog_io[35] VDD4 SUB net18 IOVSS4 IOVDD4 sg13g2_IOPadAnalog
x31 VSS4 VDD4 SUB IOVSS4 IOVDD4 IOVSS4 sg13g2_IOPadIOVdd
x32 VSS4 VDD4 SUB IOVSS4 IOVDD4 sg13g2_IOPadIOVss
x33 IOVDD4 VSS4 analog_io[34] VDD4 SUB analog_io_padres[34] IOVSS4 IOVDD4 sg13g2_IOPadAnalog
x34 IOVDD4 VSS4 analog_io[33] VDD4 SUB analog_io_padres[33] IOVSS4 IOVDD4 sg13g2_IOPadAnalog
x35 IOVDD4 VSS4 analog_io[32] VDD4 SUB net19 IOVSS4 IOVDD4 sg13g2_IOPadAnalog
x36 VSS4 VDD4 SUB IOVSS4 IOVDD4 IOVSS4 ui_PAD[31] ui_p2c[31] sg13g2_IOPadIn
x37 IOVDD4 VSS4 analog_io[30] VDD4 SUB net20 IOVSS4 IOVDD4 sg13g2_IOPadAnalog
x38 IOVDD4 VSS4 analog_io[29] VDD4 SUB analog_io_padres[29] IOVSS4 IOVDD4 sg13g2_IOPadAnalog
x39 IOVDD4 VSS4 analog_io[28] VDD4 SUB analog_io_padres[28] IOVSS4 IOVDD4 sg13g2_IOPadAnalog
x40 IOVDD4 VSS4 analog_io[27] VDD4 SUB net21 IOVSS4 IOVDD4 sg13g2_IOPadAnalog
x41 VSS4 VDD4 SUB IOVSS4 IOVDD4 IOVSS4 sg13g2_IOPadVdd
x42 VSS4 VDD4 SUB IOVSS4 IOVDD4 IOVSS4 sg13g2_IOPadVss
* noconn #net18
* noconn #net19
* noconn #net20
* noconn #net21
* noconn SUB
x43 IOVDD4 VDD4 VSS4 SUB IOVSS4 IOVSS4 IOVSS4 sg13g2_Corner_noptap
x44 IOVSS1 IOVDD1 SUB VSS1 VDD1 uo_PAD[8] uo_c2p[8] VDD1 sg13g2_IOPadOut4mA
x45 VSS1 VDD1 SUB IOVSS1 IOVDD1 IOVSS1 sg13g2_IOPadIOVdd
x46 VSS1 VDD1 SUB IOVSS1 IOVDD1 sg13g2_IOPadIOVss
x47 IOVDD1 VSS1 analog_io[7] VDD1 SUB net22 IOVSS1 IOVDD1 sg13g2_IOPadAnalog
x48 IOVDD1 VSS1 analog_io[6] VDD1 SUB analog_io_padres[6] IOVSS1 IOVDD1 sg13g2_IOPadAnalog
x49 IOVDD1 VSS1 analog_io[5] VDD1 SUB analog_io_padres[5] IOVSS1 IOVDD1 sg13g2_IOPadAnalog
x50 IOVDD1 VSS1 analog_io[4] VDD1 SUB net23 IOVSS1 IOVDD1 sg13g2_IOPadAnalog
x51 IOVSS1 IOVDD1 SUB VSS1 VDD1 uo_PAD[3] uo_c2p[3] VDD1 sg13g2_IOPadOut4mA
x52 VSS1 VDD1 SUB IOVSS1 IOVDD1 IOVSS1 ui_PAD[2] ui_p2c[2] sg13g2_IOPadIn
x53 IOVDD1 VSS1 analog_io[1] VDD1 SUB analog_io_padres[1] IOVSS1 IOVDD1 sg13g2_IOPadAnalog
x54 IOVDD1 VSS1 analog_io[0] VDD1 SUB analog_io_padres[0] IOVSS1 IOVDD1 sg13g2_IOPadAnalog
x55 VSS1 VDD1 SUB IOVSS1 IOVDD1 IOVSS1 sg13g2_IOPadVdd
x56 VSS1 VDD1 SUB IOVSS1 IOVDD1 IOVSS1 sg13g2_IOPadVss
* noconn #net22
* noconn #net23
* noconn SUB
XR4 VSS SUB ptap1 R=11.96 w=7.27e-6 l=7.27e-6
XR1 IOVSS SUB ptap1 R=0.02362 w=201.69e-6 l=201.69e-6
.ends

* expanding   symbol:  IHP__MPC0349/dependencies/IHP__OSC3593/OSC3593-main/schematic/xschem/555.sym # of pins=9
** sym_path: /foss/designs/Design/UNICASS/unic-cass-analog-team3/designs/libs/IHP__MPC0349/dependencies/IHP__OSC3593/OSC3593-main/schematic/xschem/555.sym
** sch_path: /foss/designs/Design/UNICASS/unic-cass-analog-team3/designs/libs/IHP__MPC0349/dependencies/IHP__OSC3593/OSC3593-main/schematic/xschem/555.sch
.subckt 555 VDD TRESHOLD DISCHARGE CONTROL VBIAS RESET OUTPUT TRIGGER VSS
*.opin OUTPUT
*.ipin TRIGGER
*.iopin VSS
*.ipin RESET
*.ipin TRESHOLD
*.opin DISCHARGE
*.ipin VBIAS
*.ipin CONTROL
*.iopin VDD
x1 VDD TRESHOLD CONTROL net2 VBIAS VSS Opamp
x2 VDD net1 net7 net6 net2 RESET VSS LatchJK
x3 VDD net3 TRIGGER net1 VBIAS VSS Opamp
XMN0 DISCHARGE net5 VSS VSS sg13_lv_nmos w=7.4u l=130.00n ng=1
x4 VDD net4 net6 VSS inv
x5 VDD OUTPUT net4 VSS inv
x6 VDD net5 OUTPUT VSS inv
XR1 VDD CONTROL VSS rppd w=0.5e-6 l=2e-6 m=1 b=0
XR2 CONTROL net3 VSS rppd w=0.5e-6 l=2e-6 m=1 b=0
XR3 net3 VSS VSS rppd w=0.5e-6 l=2e-6 m=1 b=0
.ends

* expanding   symbol:  IHP__MPC0349/dependencies/IHP__OPA2251/OPA2251-main/schematic/xschem/HPA.sym # of pins=7
** sym_path: /foss/designs/Design/UNICASS/unic-cass-analog-team3/designs/libs/IHP__MPC0349/dependencies/IHP__OPA2251/OPA2251-main/schematic/xschem/HPA.sym
** sch_path: /foss/designs/Design/UNICASS/unic-cass-analog-team3/designs/libs/IHP__MPC0349/dependencies/IHP__OPA2251/OPA2251-main/schematic/xschem/HPA.sch
.subckt HPA VDD VREF VOUTp VOUTn VINp VINn VSS
*.iopin VDD
*.iopin VSS
*.iopin VREF
*.ipin VINp
*.ipin VINn
*.opin VOUTn
*.opin VOUTp
x1 VDD VSS net2 net2 VOUTp VINp VINn VOUTn net3 net3 net1 VREF net1 Vop Von OTA_Telescopic_TOP_wp
* noconn Vop
* noconn Von
.ends

* expanding   symbol:  IHP__MPC0349/dependencies/IHP__OSC9996/OSC9996-main/schematic/xschem/TOP_ROILIFNEURON.sym # of pins=11
** sym_path: /foss/designs/Design/UNICASS/unic-cass-analog-team3/designs/libs/IHP__MPC0349/dependencies/IHP__OSC9996/OSC9996-main/schematic/xschem/TOP_ROILIFNEURON.sym
** sch_path: /foss/designs/Design/UNICASS/unic-cass-analog-team3/designs/libs/IHP__MPC0349/dependencies/IHP__OSC9996/OSC9996-main/schematic/xschem/TOP_ROILIFNEURON.sch
.subckt TOP_ROILIFNEURON VDD Vx2 RST SPIKEB2 VSS Vref2 COMPB2 Vx1 Vref1 SPIKEB1 COMPB1
*.opin SPIKEB1
*.opin COMPB1
*.opin SPIKEB2
*.opin COMPB2
*.iopin VDD
*.iopin VSS
*.ipin Vx1
*.ipin Vref1
*.ipin Vx2
*.ipin Vref2
*.ipin RST
xSPKB1 VDD SPIKE1 SPIKEB1 VSS gate_buff_pad
xCOMPB1 VDD COMP1 COMPB1 VSS gate_buff_pad
* noconn MEM1
* noconn MEM2
xSPKB2 VDD SPIKE2 SPIKEB2 VSS gate_buff_pad
xCOMPB2 VDD COMP2 COMPB2 VSS gate_buff_pad
xLIF1 VDD Vx1 MEM1 RST SPIKE1 VSS Vref1 COMP1 LIF_neuron
xLIF2 VDD Vx2 MEM2 RST SPIKE2 VSS Vref2 COMP2 LIF_neuron
.ends

* expanding   symbol:  IHP__MPC0349/dependencies/IHP__QDLL6501/QDLL6501-main/schematic/xschem/QDLL_TOP.sym # of pins=10
** sym_path: /foss/designs/Design/UNICASS/unic-cass-analog-team3/designs/libs/IHP__MPC0349/dependencies/IHP__QDLL6501/QDLL6501-main/schematic/xschem/QDLL_TOP.sym
** sch_path: /foss/designs/Design/UNICASS/unic-cass-analog-team3/designs/libs/IHP__MPC0349/dependencies/IHP__QDLL6501/QDLL6501-main/schematic/xschem/QDLL_TOP.sch
.subckt QDLL_TOP VDD VSS IN1 OUT1 OUT2 IN2 CPOUT2 VCONT2 IN3 OUT3
*.iopin VDD
*.iopin VSS
*.ipin IN1
*.ipin IN2
*.opin OUT1
*.opin OUT2
*.opin CPOUT2
*.ipin VCONT2
*.opin OUT3
*.ipin IN3
*  x1 -  SE_QDLL  IS MISSING !!!!
*  x2 -  SE_QDLL  IS MISSING !!!!
*  x3 -  DLine  IS MISSING !!!!
.ends

* expanding   symbol:  IHP__MPC0349/dependencies/IHP__OSC3593/OSC3593-main/schematic/xschem/PWMADCSYM.sym # of pins=6
** sym_path: /foss/designs/Design/UNICASS/unic-cass-analog-team3/designs/libs/IHP__MPC0349/dependencies/IHP__OSC3593/OSC3593-main/schematic/xschem/PWMADCSYM.sym
** sch_path: /foss/designs/Design/UNICASS/unic-cass-analog-team3/designs/libs/IHP__MPC0349/dependencies/IHP__OSC3593/OSC3593-main/schematic/xschem/PWMADCSYM.sch
.subckt PWMADCSYM VDD VIN VBIAS PWM CLK VSS
*.opin PWM
*.iopin VSS
*.iopin VDD
*.ipin VIN
*.ipin VBIAS
*.ipin CLK
x1 VDD VBIAS VIN VSS net1 net2 net3 flashadcSym
x2 VDD net5 net4 net6 CLK VSS cont3
x3 net6 PWM net3 net5 net2 net4 net1 VDD VSS 3bitcomparator
.ends

* expanding   symbol:  sg13g2_Corner_noptap.sym # of pins=7
** sym_path: /foss/designs/Design/UNICASS/unic-cass-analog-team3/designs/openpdk-libraries/ihp-sg13g2/sg13g2_io/xschem/sg13g2_Corner_noptap.sym
** sch_path: /foss/designs/Design/UNICASS/unic-cass-analog-team3/designs/openpdk-libraries/ihp-sg13g2/sg13g2_io/xschem/sg13g2_Corner_noptap.sch
.subckt sg13g2_Corner_noptap iovdd vdd vss sub iovss1 iovss3 iovss2
*.iopin vss
*.iopin iovdd
*.iopin vdd
*.iopin sub
*.iopin iovss1
*.iopin iovss2
*.iopin iovss3
* noconn iovdd
* noconn vdd
.ends

* expanding   symbol:  sg13g2_IOPadIn.sym # of pins=8
** sym_path: /foss/designs/Design/UNICASS/unic-cass-analog-team3/designs/openpdk-libraries/ihp-sg13g2/sg13g2_io/xschem/sg13g2_IOPadIn.sym
** sch_path: /foss/designs/Design/UNICASS/unic-cass-analog-team3/designs/openpdk-libraries/ihp-sg13g2/sg13g2_io/xschem/sg13g2_IOPadIn.sch
.subckt sg13g2_IOPadIn vss vdd ! iovss iovdd iovss1 pad p2c
*.iopin iovdd
*.iopin vss
*.iopin vdd
*.iopin !
*.iopin iovss
*.iopin iovss1
*.iopin pad
*.iopin p2c
XR2 vss ! ptap1 R=22.47 w=4.9e-6 l=4.9e-6
XR1 iovss1 ! ptap1 R=0.1716 w=73.6e-6 l=73.6e-6
x4 iovdd iovss1 pad p2c vdd vss ! sg13g2_LevelDown_noptap
x2 iovdd ! pad pad ! sg13g2_DCPDiode_noptap
x1 pad iovss pad iovdd ! sg13g2_DCNDiode
.ends

* expanding   symbol:  sg13g2_IOPadVss.sym # of pins=6
** sym_path: /foss/designs/Design/UNICASS/unic-cass-analog-team3/designs/openpdk-libraries/ihp-sg13g2/sg13g2_io/xschem/sg13g2_IOPadVss.sym
** sch_path: /foss/designs/Design/UNICASS/unic-cass-analog-team3/designs/openpdk-libraries/ihp-sg13g2/sg13g2_io/xschem/sg13g2_IOPadVss.sch
.subckt sg13g2_IOPadVss vss vdd sub iovss iovdd iovss1
*.iopin iovdd
*.iopin vss
*.iopin vdd
*.iopin sub
*.iopin iovss
*.iopin iovss1
XR2 vss sub ptap1 R=22.47 w=4.9e-6 l=4.9e-6
x2 iovdd sub vss vss sub sg13g2_DCPDiode_noptap
x4 vss iovss vss iovdd sub sg13g2_DCNDiode
* noconn vdd
XR1 iovss1 sub ptap1 R=0.1719 w=73.54e-6 l=73.54e-6
.ends

* expanding   symbol:  sg13g2_Filler4000.sym # of pins=7
** sym_path: /foss/designs/Design/UNICASS/unic-cass-analog-team3/designs/openpdk-libraries/ihp-sg13g2/sg13g2_io/xschem/sg13g2_Filler4000.sym
** sch_path: /foss/designs/Design/UNICASS/unic-cass-analog-team3/designs/openpdk-libraries/ihp-sg13g2/sg13g2_io/xschem/sg13g2_Filler4000.sch
.subckt sg13g2_Filler4000 iovdd iovss1 vdd iovss2 iovss3 vss sub
*.iopin iovss1
*.iopin iovss2
*.iopin iovss3
*.iopin vss
*.iopin iovdd
*.iopin vdd
*.iopin sub
XR3 iovss3 sub ptap1 R=1.7 w=19.5e-6 l=25e-6
XR4 vss sub ptap1 R=21.56 w=0.3e-6 l=19.5e-6
* noconn iovdd
* noconn vdd
XR1 iovss1 sub ptap1 R=1.7 w=19.5e-6 l=25e-6
XR2 iovss2 sub ptap1 R=1.7 w=19.5e-6 l=25e-6
.ends

* expanding   symbol:  sg13g2_Filler1000.sym # of pins=7
** sym_path: /foss/designs/Design/UNICASS/unic-cass-analog-team3/designs/openpdk-libraries/ihp-sg13g2/sg13g2_io/xschem/sg13g2_Filler1000.sym
** sch_path: /foss/designs/Design/UNICASS/unic-cass-analog-team3/designs/openpdk-libraries/ihp-sg13g2/sg13g2_io/xschem/sg13g2_Filler1000.sch
.subckt sg13g2_Filler1000 iovdd iovss1 vdd iovss2 iovss3 vss sub
*.iopin iovss1
*.iopin iovss2
*.iopin iovss3
*.iopin vss
*.iopin iovdd
*.iopin vdd
*.iopin sub
XR3 iovss3 sub ptap1 R=5.806 w=4.4e-6 l=25e-6
XR4 vss sub ptap1 R=87.86 w=0.31e-6 l=4.56e-6
* noconn iovdd
* noconn vdd
XR1 iovss1 sub ptap1 R=5.806 w=4.4e-6 l=25e-6
XR2 iovss2 sub ptap1 R=5.806 w=4.4e-6 l=25e-6
.ends

* expanding   symbol:  sg13g2_Filler400.sym # of pins=7
** sym_path: /foss/designs/Design/UNICASS/unic-cass-analog-team3/designs/openpdk-libraries/ihp-sg13g2/sg13g2_io/xschem/sg13g2_Filler400.sym
** sch_path: /foss/designs/Design/UNICASS/unic-cass-analog-team3/designs/openpdk-libraries/ihp-sg13g2/sg13g2_io/xschem/sg13g2_Filler400.sch
.subckt sg13g2_Filler400 iovdd iovss1 vdd iovss2 iovss3 vss sub
*.iopin iovss1
*.iopin iovss2
*.iopin iovss3
*.iopin vss
*.iopin iovdd
*.iopin vdd
*.iopin sub
XR3 iovss3 sub ptap1 R=10.85 w=1.56e-6 l=24.5e-6
XR4 vss sub ptap1 R=208 w=0.42e-6 l=1.6e-6
* noconn iovdd
* noconn vdd
XR1 iovss1 sub ptap1 R=10.85 w=1.56e-6 l=24.5e-6
XR2 iovss2 sub ptap1 R=10.85 w=1.56e-6 l=24.5e-6
.ends

* expanding   symbol:  sg13g2_Filler200.sym # of pins=7
** sym_path: /foss/designs/Design/UNICASS/unic-cass-analog-team3/designs/openpdk-libraries/ihp-sg13g2/sg13g2_io/xschem/sg13g2_Filler200.sym
** sch_path: /foss/designs/Design/UNICASS/unic-cass-analog-team3/designs/openpdk-libraries/ihp-sg13g2/sg13g2_io/xschem/sg13g2_Filler200.sch
.subckt sg13g2_Filler200 iovdd iovss1 vdd iovss2 iovss3 vss sub
*.iopin iovss1
*.iopin iovss2
*.iopin iovss3
*.iopin vss
*.iopin iovdd
*.iopin vdd
*.iopin sub
XR3 iovss3 sub ptap1 R=15.35 w=0.56e-6 l=24.5e-6
XR4 vss sub ptap1 R=182.8 w=0.34e-6 l=2.0e-6
XR1 iovss1 sub ptap1 R=15.35 w=0.56e-6 l=24.5e-6
XR2 iovss2 sub ptap1 R=15.35 w=0.56e-6 l=24.5e-6
* noconn iovdd
* noconn vdd
.ends

* expanding   symbol:  sg13g2_IOPadVdd.sym # of pins=6
** sym_path: /foss/designs/Design/UNICASS/unic-cass-analog-team3/designs/openpdk-libraries/ihp-sg13g2/sg13g2_io/xschem/sg13g2_IOPadVdd.sym
** sch_path: /foss/designs/Design/UNICASS/unic-cass-analog-team3/designs/openpdk-libraries/ihp-sg13g2/sg13g2_io/xschem/sg13g2_IOPadVdd.sch
.subckt sg13g2_IOPadVdd vss vdd ! iovss iovdd iovss1
*.iopin iovdd
*.iopin vss
*.iopin vdd
*.iopin !
*.iopin iovss1
*.iopin iovss
XR2 vss ! ptap1 R=22.47 w=4.9e-6 l=4.9e-6
XR1 iovss1 ! ptap1 R=0.4388 w=45.3e-6 l=45.3e-6
x1 iovss vdd vdd vdd vdd vdd vdd vdd vdd vdd vdd vdd vdd vdd vdd vdd vdd vdd vdd vdd vdd vdd vdd ! net2 sg13g2_Clamp_N43N43D4R
x2 vdd net1 ! sg13g2_RCClampResistor
x3 vdd iovss1 net1 net2 ! sg13g2_RCClampInverter_noptap
* noconn iovdd
.ends

* expanding   symbol:  sg13g2_IOPadAnalog.sym # of pins=8
** sym_path: /foss/designs/Design/UNICASS/unic-cass-analog-team3/designs/openpdk-libraries/ihp-sg13g2/sg13g2_io/xschem/sg13g2_IOPadAnalog.sym
** sch_path: /foss/designs/Design/UNICASS/unic-cass-analog-team3/designs/openpdk-libraries/ihp-sg13g2/sg13g2_io/xschem/sg13g2_IOPadAnalog.sch
.subckt sg13g2_IOPadAnalog iovdd1 vss pad vdd ! padres iovss iovdd
*.iopin padres
*.iopin iovdd
*.iopin vss
*.iopin vdd
*.iopin !
*.iopin iovss
*.iopin pad
*.iopin iovdd1
XR2 vss ! ptap1 R=22.54 w=4.89e-6 l=4.89e-6
x1 iovdd iovss pad pad pad pad pad pad pad pad pad pad ! sg13g2_Clamp_P20N0D_noptap
x2 iovdd ! pad pad ! sg13g2_DCPDiode_noptap
x3 iovss pad pad pad pad pad pad pad pad pad pad ! sg13g2_Clamp_N20N0D
x4 pad iovss pad iovdd ! sg13g2_DCNDiode
x5 padres iovdd1 iovss pad ! sg13g2_SecondaryProtection
* noconn vdd
XR1 iovss ! ptap1 R=0.2112 w=66.14e-6 l=66.14e-6
.ends

* expanding   symbol:  sg13g2_IOPadIOVdd.sym # of pins=6
** sym_path: /foss/designs/Design/UNICASS/unic-cass-analog-team3/designs/openpdk-libraries/ihp-sg13g2/sg13g2_io/xschem/sg13g2_IOPadIOVdd.sym
** sch_path: /foss/designs/Design/UNICASS/unic-cass-analog-team3/designs/openpdk-libraries/ihp-sg13g2/sg13g2_io/xschem/sg13g2_IOPadIOVdd.sch
.subckt sg13g2_IOPadIOVdd vss vdd ! iovss iovdd iovss1
*.iopin iovdd
*.iopin vss
*.iopin vdd
*.iopin !
*.iopin iovss1
*.iopin iovss
XR2 vss ! ptap1 R=22.47 w=4.9e-6 l=4.9e-6
* noconn vdd
XR1 iovss1 ! ptap1 R=0.4388 w=45.3e-6 l=45.3e-6
x1 iovss iovdd iovdd iovdd iovdd iovdd iovdd iovdd iovdd iovdd iovdd iovdd iovdd iovdd iovdd iovdd iovdd iovdd iovdd iovdd iovdd
+ iovdd iovdd ! net2 sg13g2_Clamp_N43N43D4R
x2 iovdd net1 ! sg13g2_RCClampResistor
x3 iovdd iovss1 net1 net2 ! sg13g2_RCClampInverter_noptap
.ends

* expanding   symbol:  sg13g2_IOPadIOVss.sym # of pins=5
** sym_path: /foss/designs/Design/UNICASS/unic-cass-analog-team3/designs/openpdk-libraries/ihp-sg13g2/sg13g2_io/xschem/sg13g2_IOPadIOVss.sym
** sch_path: /foss/designs/Design/UNICASS/unic-cass-analog-team3/designs/openpdk-libraries/ihp-sg13g2/sg13g2_io/xschem/sg13g2_IOPadIOVss.sch
.subckt sg13g2_IOPadIOVss vss vdd sub iovss iovdd
*.iopin iovdd
*.iopin vss
*.iopin vdd
*.iopin sub
*.iopin iovss
XR2 vss sub ptap1 R=22.47 w=4.9e-6 l=4.9e-6
* noconn vdd
XR1 iovss sub ptap1 R=0.1716 w=73.6e-6 l=73.6e-6
x2 iovdd sub iovss iovss sub sg13g2_DCPDiode_noptap
x1 iovss iovss iovss iovdd sub sg13g2_DCNDiode
.ends

* expanding   symbol:  sg13g2_IOPadOut4mA.sym # of pins=8
** sym_path: /foss/designs/Design/UNICASS/unic-cass-analog-team3/designs/openpdk-libraries/ihp-sg13g2/sg13g2_io/xschem/sg13g2_IOPadOut4mA.sym
** sch_path: /foss/designs/Design/UNICASS/unic-cass-analog-team3/designs/openpdk-libraries/ihp-sg13g2/sg13g2_io/xschem/sg13g2_IOPadOut4mA.sch
.subckt sg13g2_IOPadOut4mA vss vdd sub iovss iovdd1 c2p pad iovdd
*.iopin iovdd1
*.iopin vss
*.iopin vdd
*.iopin sub
*.iopin iovss
*.iopin iovdd
*.iopin pad
*.iopin c2p
XR2 vss sub ptap1 R=22.47 w=4.9e-6 l=4.9e-6
XR1 iovss sub ptap1 R=0.2094 w=66.44e-6 l=66.44e-6
x2 iovdd sub pad pad sub sg13g2_DCPDiode_noptap
x1 pad iovss pad iovdd sub sg13g2_DCNDiode
x3 iovdd1 vss c2p net1 vdd sub net2 sg13g2_GateLevelUpInv_noptap
x4 net2 pad iovss sub sg13g2_Clamp_N2N2D
x5 net1 iovdd iovss pad sub sg13g2_Clamp_P2N2D_noptap
.ends

* expanding   symbol:  Opamp.sym # of pins=6
** sym_path: /foss/designs/Design/UNICASS/unic-cass-analog-team3/designs/libs/IHP__MPC0349/dependencies/IHP__OSC3593/OSC3593-main/schematic/xschem/Opamp.sym
** sch_path: /foss/designs/Design/UNICASS/unic-cass-analog-team3/designs/libs/IHP__MPC0349/dependencies/IHP__OSC3593/OSC3593-main/schematic/xschem/Opamp.sch
.subckt Opamp VDD Vin Vref Vout Vbias VSS
*.ipin Vin
*.iopin VDD
*.iopin VSS
*.ipin Vref
*.opin Vout
*.ipin Vbias
XMP5 net4 net4 VDD VDD sg13_lv_pmos w=10u l=150.00n ng=1
XMP6 net1 net4 VDD VDD sg13_lv_pmos w=10u l=150.00n ng=1
XMN4 net3 net2 VSS VSS sg13_lv_nmos w=420.00n l=560.00n ng=1
XMN5 net2 net2 VSS VSS sg13_lv_nmos w=420.00n l=560.00n ng=1
XMN6 net4 Vbias VSS VSS sg13_lv_nmos w=500.00n l=150.00n ng=1
XMP7 net2 Vref net1 VDD sg13_lv_pmos w=10u l=300.00n ng=1
XMP8 net3 Vin net1 VDD sg13_lv_pmos w=10u l=300.00n ng=1
XMN7 Vout net3 VSS VSS sg13_lv_nmos w=420.00n l=560.00n ng=1
XMP9 Vout net4 VDD VDD sg13_lv_pmos w=5u l=150.00n ng=1
.ends

* expanding   symbol:  LatchJK.sym # of pins=7
** sym_path: /foss/designs/Design/UNICASS/unic-cass-analog-team3/designs/libs/IHP__MPC0349/dependencies/IHP__OSC3593/OSC3593-main/schematic/xschem/LatchJK.sym
** sch_path: /foss/designs/Design/UNICASS/unic-cass-analog-team3/designs/libs/IHP__MPC0349/dependencies/IHP__OSC3593/OSC3593-main/schematic/xschem/LatchJK.sch
.subckt LatchJK VDD S Qn Q R Rn VSS
*.opin Qn
*.ipin Rn
*.iopin VDD
*.iopin VSS
*.ipin R
*.ipin S
*.opin Q
x2 VDD Q S Qn VSS NOR
x21 VDD net2 Qn Q VSS NOR
x22 VDD net1 Rn net2 VSS NAND
x25 VDD net1 R VSS inv
.ends

* expanding   symbol:  inv.sym # of pins=4
** sym_path: /foss/designs/Design/UNICASS/unic-cass-analog-team3/designs/libs/IHP__MPC0349/dependencies/IHP__OSC3593/OSC3593-main/schematic/xschem/inv.sym
** sch_path: /foss/designs/Design/UNICASS/unic-cass-analog-team3/designs/libs/IHP__MPC0349/dependencies/IHP__OSC3593/OSC3593-main/schematic/xschem/inv.sch
.subckt inv VDD Y A VSS
*.opin Y
*.ipin A
*.iopin VDD
*.iopin VSS
XMN0 Y A VSS VSS sg13_lv_nmos w=740.00n l=130.00n ng=1
XMP0 Y A VDD VDD sg13_lv_pmos w=1.12u l=130.00n ng=1
.ends

* expanding   symbol:  OTA_Telescopic_TOP_wp.sym # of pins=15
** sym_path: /foss/designs/Design/UNICASS/unic-cass-analog-team3/designs/libs/IHP__MPC0349/dependencies/IHP__OPA2251/OPA2251-main/schematic/xschem/OTA_Telescopic_TOP_wp.sym
** sch_path: /foss/designs/Design/UNICASS/unic-cass-analog-team3/designs/libs/IHP__MPC0349/dependencies/IHP__OPA2251/OPA2251-main/schematic/xschem/OTA_Telescopic_TOP_wp.sch
.subckt OTA_Telescopic_TOP_wp VDD VSS VPout VPin VOUTP VP VN VOUTN VNin VNout CMFBin VREF CMFBout Vop Von
*.ipin VP
*.ipin VN
*.opin VOUTP
*.opin VOUTN
*.ipin VPin
*.ipin VNin
*.opin VPout
*.opin VNout
*.iopin VDD
*.iopin VSS
*.iopin VREF
*.ipin CMFBin
*.opin CMFBout
*.opin Von
*.opin Vop
x3 VDD I_P I_N VSS I_P2 I_P3 OTA_Telescopic_currentRef
x2 VDD VREF Vop Von I_N CMFBout VSS OTA_Telescopic_CMFB
x1 I_P VPout VP VPin Vop VDD Von VSS VNin VNout VN CMFBin OTA_Telescopic_FB
x4 VDD VOUTN I_P2 Von VSS Buffer
x5 VDD VOUTP I_P3 Vop VSS Buffer
.ends

* expanding   symbol:  gate_buff_pad.sym # of pins=4
** sym_path: /foss/designs/Design/UNICASS/unic-cass-analog-team3/designs/libs/IHP__MPC0349/dependencies/IHP__OSC9996/OSC9996-main/schematic/xschem/gate_buff_pad.sym
** sch_path: /foss/designs/Design/UNICASS/unic-cass-analog-team3/designs/libs/IHP__MPC0349/dependencies/IHP__OSC9996/OSC9996-main/schematic/xschem/gate_buff_pad.sch
.subckt gate_buff_pad VDD VIN VOUT VSS
*.ipin VDD
*.ipin VIN
*.ipin VSS
*.opin VOUT
XMN1 X VIN VSS VSS sg13_lv_nmos w=4.8u l=0.13u ng=1
XMP1 X VIN VDD VDD sg13_lv_pmos w=9.6u l=0.13u ng=1
XMN2 Y X VSS VSS sg13_lv_nmos w=4.8u l=0.13u ng=1 m=4
XMP2 Y X VDD VDD sg13_lv_pmos w=9.6u l=0.13u ng=1 m=4
XMN3 Z Y VSS VSS sg13_lv_nmos w=4.8u l=0.13u ng=1 m=16
XMP3 Z Y VDD VDD sg13_lv_pmos w=9.6u l=0.13u ng=1 m=16
XMN4 VOUT Z VSS VSS sg13_lv_nmos w=4.8u l=0.13u ng=1 m=64
XMP4 VOUT Z VDD VDD sg13_lv_pmos w=9.6u l=0.13u ng=1 m=64
.ends

* expanding   symbol:  LIF_neuron.sym # of pins=8
** sym_path: /foss/designs/Design/UNICASS/unic-cass-analog-team3/designs/libs/IHP__MPC0349/dependencies/IHP__OSC9996/OSC9996-main/schematic/xschem/LIF_neuron.sym
** sch_path: /foss/designs/Design/UNICASS/unic-cass-analog-team3/designs/libs/IHP__MPC0349/dependencies/IHP__OSC9996/OSC9996-main/schematic/xschem/LIF_neuron.sch
.subckt LIF_neuron VDD Vx MEM RST SPIKE VSS Vref COMP
*.iopin VDD
*.iopin VSS
*.opin MEM
*.ipin Vx
*.ipin Vref
*.opin SPIKE
*.ipin RST
*.opin COMP
xINT Vref VSS VDD INT_RST Vx MEM integrator
xSPK VDD COMP SPIKE INT_RST RST VSS spike_generator
xRES VDD MEM Vx resistence_bank
xCOMP VDD MEM COMP VSS threshold_comparator
.ends

* expanding   symbol:  flashadcSym.sym # of pins=7
** sym_path: /foss/designs/Design/UNICASS/unic-cass-analog-team3/designs/libs/IHP__MPC0349/dependencies/IHP__OSC3593/OSC3593-main/schematic/xschem/flashadcSym.sym
** sch_path: /foss/designs/Design/UNICASS/unic-cass-analog-team3/designs/libs/IHP__MPC0349/dependencies/IHP__OSC3593/OSC3593-main/schematic/xschem/flashadcSym.sch
.subckt flashadcSym VDD vbias vin GND A B C
*.iopin VDD
*.iopin GND
*.ipin vbias
*.ipin vin
*.opin B
*.opin A
*.opin C
x9 VDD vin ref1 D1 vbias GND Opamp
x10 VDD vin ref2 D2 vbias GND Opamp
x11 VDD vin ref3 D3 vbias GND Opamp
x12 VDD vin ref4 D4 vbias GND Opamp
x13 VDD vin ref5 D5 vbias GND Opamp
x14 VDD vin ref6 D6 vbias GND Opamp
x15 VDD vin ref7 D7 vbias GND Opamp
x4 VDD net2 D4 GND inv
x16 VDD net2 D2 net3 GND NAND
x1 VDD net4 net3 B GND NAND
x3 VDD net4 D6 GND inv
x6 VDD net5 D2 GND inv
x17 VDD net7 D7 GND inv
x18 VDD net8 D4 GND inv
x20 VDD net9 D6 GND inv
x7 VDD net5 D1 net6 GND NAND
x19 VDD net9 D5 net10 GND NAND
x21 VDD net8 D3 net11 GND NAND
x8 VDD net7 net6 C2 GND NAND
x22 VDD net10 net11 C1 GND NAND
x23 VDD net12 C2 GND inv
x24 VDD net13 C1 GND inv
x25 VDD net13 net12 A GND NAND
x2 VDD net14 D4 GND inv
x5 VDD C net14 GND inv
XR1 ref1 GND GND rppd w=0.5e-6 l=4e-6 m=1 b=0
XR8 ref2 ref1 GND rppd w=0.5e-6 l=2e-6 m=1 b=0
XR7 ref3 ref2 GND rppd w=0.5e-6 l=2e-6 m=1 b=0
XR6 ref4 ref3 GND rppd w=0.5e-6 l=2e-6 m=1 b=0
XR5 ref5 ref4 GND rppd w=0.5e-6 l=2e-6 m=1 b=0
XR4 ref6 ref5 GND rppd w=0.5e-6 l=2e-6 m=1 b=0
XR3 ref7 ref6 GND rppd w=0.5e-6 l=2e-6 m=1 b=0
XR2 VDD net1 GND rppd w=0.5e-6 l=2e-6 m=1 b=0
XR9 net1 ref7 GND rppd w=0.5e-6 l=2e-6 m=1 b=0
.ends

* expanding   symbol:  cont3.sym # of pins=6
** sym_path: /foss/designs/Design/UNICASS/unic-cass-analog-team3/designs/libs/IHP__MPC0349/dependencies/IHP__OSC3593/OSC3593-main/schematic/xschem/cont3.sym
** sch_path: /foss/designs/Design/UNICASS/unic-cass-analog-team3/designs/libs/IHP__MPC0349/dependencies/IHP__OSC3593/OSC3593-main/schematic/xschem/cont3.sch
.subckt cont3 VDD B A C CLK VSS
*.opin B
*.iopin CLK
*.iopin VDD
*.iopin VSS
*.opin C
*.opin A
x1 CLK net1 VDD A net1 VSS flipflopn
x2 A net2 VDD B net2 VSS flipflopn
x3 B net3 VDD C net3 VSS flipflopn
.ends

* expanding   symbol:  3bitcomparator.sym # of pins=9
** sym_path: /foss/designs/Design/UNICASS/unic-cass-analog-team3/designs/libs/IHP__MPC0349/dependencies/IHP__OSC3593/OSC3593-main/schematic/xschem/3bitcomparator.sym
** sch_path: /foss/designs/Design/UNICASS/unic-cass-analog-team3/designs/libs/IHP__MPC0349/dependencies/IHP__OSC3593/OSC3593-main/schematic/xschem/3bitcomparator.sch
.subckt 3bitcomparator B2 PWM A2 B1 A1 B0 A0 VDD VSS
*.iopin VDD
*.iopin VSS
*.ipin A2
*.ipin B2
*.ipin A1
*.ipin B1
*.ipin A0
*.ipin B0
*.opin PWM
x28 VDD net1 B2 net6 VSS NAND
x29 VDD net1 A2 VSS inv
x3 VDD net2 B1 net3 VSS NAND
x6 VDD net2 A1 VSS inv
x9 VDD net10 net11 net4 VSS NAND
x11 VDD net11 net3 VSS inv
x12 VDD B2 A2 net5 VSS NAND
x4 VDD net5 A2 net7 VSS NAND
x5 VDD net5 B2 net8 VSS NAND
x15 VDD net8 net7 net9 VSS NAND
x21 VDD net10 net9 VSS inv
x2 VDD net12 B0 net13 VSS NAND
x7 VDD net12 A0 VSS inv
x8 VDD net18 net19 net20 VSS NAND
x10 VDD net19 net13 VSS inv
x13 VDD B1 A1 net14 VSS NAND
x14 VDD net14 A1 net15 VSS NAND
x16 VDD net14 B1 net16 VSS NAND
x17 VDD net16 net15 net17 VSS NAND
x18 VDD net18 net17 VSS inv
x19 VDD net6 net4 net22 PWM VSS AND3
x22 VDD net21 net20 VSS inv
x23 VDD net21 net10 net22 VSS NAND
.ends

* expanding   symbol:  sg13g2_LevelDown_noptap.sym # of pins=7
** sym_path: /foss/designs/Design/UNICASS/unic-cass-analog-team3/designs/openpdk-libraries/ihp-sg13g2/sg13g2_io/xschem/sg13g2_LevelDown_noptap.sym
** sch_path: /foss/designs/Design/UNICASS/unic-cass-analog-team3/designs/openpdk-libraries/ihp-sg13g2/sg13g2_io/xschem/sg13g2_LevelDown_noptap.sch
.subckt sg13g2_LevelDown_noptap iovdd iovss pad core vdd vss !
*.iopin iovdd
*.iopin vss
*.iopin core
*.iopin pad
*.iopin vdd
*.iopin iovss
*.iopin !
XM5 net2 net1 vdd vdd sg13_hv_pmos w=4.65u l=0.45u ng=1
XM6 net2 net1 vss ! sg13_hv_nmos w=2.65u l=0.45u ng=1
XM7 core net2 vss ! sg13_lv_nmos w=2.75u l=0.13u ng=1
XM8 core net2 vdd vdd sg13_lv_pmos w=4.75u l=0.13u ng=1
x1 net1 iovdd iovss pad ! sg13g2_SecondaryProtection_noptap
.ends

* expanding   symbol:  sg13g2_DCPDiode_noptap.sym # of pins=5
** sym_path: /foss/designs/Design/UNICASS/unic-cass-analog-team3/designs/openpdk-libraries/ihp-sg13g2/sg13g2_io/xschem/sg13g2_DCPDiode_noptap.sym
** sch_path: /foss/designs/Design/UNICASS/unic-cass-analog-team3/designs/openpdk-libraries/ihp-sg13g2/sg13g2_io/xschem/sg13g2_DCPDiode_noptap.sch
.subckt sg13g2_DCPDiode_noptap cathode guard anode1 anode2 sub
*.iopin anode2
*.iopin cathode
*.iopin guard
*.iopin anode1
*.iopin sub
XD1 anode1 cathode dpantenna l=27.78u w=1.26u
XD2 anode2 cathode dpantenna l=27.78u w=1.26u
.ends

* expanding   symbol:  sg13g2_DCNDiode.sym # of pins=5
** sym_path: /foss/designs/Design/UNICASS/unic-cass-analog-team3/designs/openpdk-libraries/ihp-sg13g2/sg13g2_io/xschem/sg13g2_DCNDiode.sym
** sch_path: /foss/designs/Design/UNICASS/unic-cass-analog-team3/designs/openpdk-libraries/ihp-sg13g2/sg13g2_io/xschem/sg13g2_DCNDiode.sch
.subckt sg13g2_DCNDiode cathode1 anode cathode2 guard sub
*.iopin cathode2
*.iopin guard
*.iopin anode
*.iopin cathode1
*.iopin sub
XR1 anode sub ptap1 R=5.179 w=11.9e-6 l=11.9e-6
XD1 sub cathode1 dantenna l=27.78u w=1.26u
* noconn guard
XD2 sub cathode2 dantenna l=27.78u w=1.26u
.ends

* expanding   symbol:  sg13g2_Clamp_N43N43D4R.sym # of pins=4
** sym_path: /foss/designs/Design/UNICASS/unic-cass-analog-team3/designs/openpdk-libraries/ihp-sg13g2/sg13g2_io/xschem/sg13g2_Clamp_N43N43D4R.sym
** sch_path: /foss/designs/Design/UNICASS/unic-cass-analog-team3/designs/openpdk-libraries/ihp-sg13g2/sg13g2_io/xschem/sg13g2_Clamp_N43N43D4R.sch
.subckt sg13g2_Clamp_N43N43D4R iovss pad[21] pad[20] pad[19] pad[18] pad[17] pad[16] pad[15] pad[14] pad[13] pad[12] pad[11]
+ pad[10] pad[9] pad[8] pad[7] pad[6] pad[5] pad[4] pad[3] pad[2] pad[1] pad[0] sub gate
*.iopin iovss
*.iopin
*+ pad[21],pad[20],pad[19],pad[18],pad[17],pad[16],pad[15],pad[14],pad[13],pad[12],pad[11],pad[10],pad[9],pad[8],pad[7],pad[6],pad[5],pad[4],pad[3],pad[2],pad[1],pad[0]
*.iopin sub
*.iopin gate
XR1 iovss sub ptap1 R=9.999 w=8.1e-6 l=8.1e-6
XM1 pad[11] gate iovss sub sg13_hv_nmos w=35.2u l=0.6u ng=8
XM2 pad[12] gate iovss sub sg13_hv_nmos w=35.2u l=0.6u ng=8
XM3 pad[13] gate iovss sub sg13_hv_nmos w=35.2u l=0.6u ng=8
XM4 pad[14] gate iovss sub sg13_hv_nmos w=35.2u l=0.6u ng=8
XM5 pad[15] gate iovss sub sg13_hv_nmos w=35.2u l=0.6u ng=8
XM6 pad[16] gate iovss sub sg13_hv_nmos w=35.2u l=0.6u ng=8
XM7 pad[17] gate iovss sub sg13_hv_nmos w=35.2u l=0.6u ng=8
XM8 pad[18] gate iovss sub sg13_hv_nmos w=35.2u l=0.6u ng=8
XM9 pad[19] gate iovss sub sg13_hv_nmos w=35.2u l=0.6u ng=8
XM10 pad[20] gate iovss sub sg13_hv_nmos w=35.2u l=0.6u ng=8
XM11 pad[21] gate iovss sub sg13_hv_nmos w=17.6u l=0.6u ng=4
XD1 sub gate dantenna l=0.48u w=0.48u
XM12 pad[0] gate iovss sub sg13_hv_nmos w=35.2u l=0.6u ng=8
XM13 pad[1] gate iovss sub sg13_hv_nmos w=35.2u l=0.6u ng=8
XM14 pad[2] gate iovss sub sg13_hv_nmos w=35.2u l=0.6u ng=8
XM15 pad[3] gate iovss sub sg13_hv_nmos w=35.2u l=0.6u ng=8
XM16 pad[4] gate iovss sub sg13_hv_nmos w=35.2u l=0.6u ng=8
XM17 pad[5] gate iovss sub sg13_hv_nmos w=35.2u l=0.6u ng=8
XM18 pad[6] gate iovss sub sg13_hv_nmos w=35.2u l=0.6u ng=8
XM19 pad[7] gate iovss sub sg13_hv_nmos w=35.2u l=0.6u ng=8
XM20 pad[8] gate iovss sub sg13_hv_nmos w=35.2u l=0.6u ng=8
XM21 pad[9] gate iovss sub sg13_hv_nmos w=35.2u l=0.6u ng=8
XM22 pad[10] gate iovss sub sg13_hv_nmos w=35.2u l=0.6u ng=8
.ends

* expanding   symbol:  sg13g2_RCClampResistor.sym # of pins=3
** sym_path: /foss/designs/Design/UNICASS/unic-cass-analog-team3/designs/openpdk-libraries/ihp-sg13g2/sg13g2_io/xschem/sg13g2_RCClampResistor.sym
** sch_path: /foss/designs/Design/UNICASS/unic-cass-analog-team3/designs/openpdk-libraries/ihp-sg13g2/sg13g2_io/xschem/sg13g2_RCClampResistor.sch
.subckt sg13g2_RCClampResistor p1 p2 !
*.iopin p1
*.iopin p2
*.iopin !
XR1 p1 p2 sub! rppd w=1e-6 l=520e-6 m=1 b=0
.ends

* expanding   symbol:  sg13g2_RCClampInverter_noptap.sym # of pins=5
** sym_path: /foss/designs/Design/UNICASS/unic-cass-analog-team3/designs/openpdk-libraries/ihp-sg13g2/sg13g2_io/xschem/sg13g2_RCClampInverter_noptap.sym
** sch_path: /foss/designs/Design/UNICASS/unic-cass-analog-team3/designs/openpdk-libraries/ihp-sg13g2/sg13g2_io/xschem/sg13g2_RCClampInverter_noptap.sch
.subckt sg13g2_RCClampInverter_noptap supply iovss in out sub
*.iopin supply
*.iopin iovss
*.iopin out
*.iopin in
*.iopin sub
XM1 iovss in iovss sub sg13_hv_nmos w=126u l=9.5u ng=14
XM2 out in iovss sub sg13_hv_nmos w=108u l=0.5u ng=12
XM3 out in supply supply sg13_hv_pmos w=350u l=0.5u ng=50
.ends

* expanding   symbol:  sg13g2_Clamp_P20N0D_noptap.sym # of pins=4
** sym_path: /foss/designs/Design/UNICASS/unic-cass-analog-team3/designs/openpdk-libraries/ihp-sg13g2/sg13g2_io/xschem/sg13g2_Clamp_P20N0D_noptap.sym
** sch_path: /foss/designs/Design/UNICASS/unic-cass-analog-team3/designs/openpdk-libraries/ihp-sg13g2/sg13g2_io/xschem/sg13g2_Clamp_P20N0D_noptap.sch
.subckt sg13g2_Clamp_P20N0D_noptap ! iovss pad[9] pad[8] pad[7] pad[6] pad[5] pad[4] pad[3] pad[2] pad[1] pad[0] sub
*.iopin iovss
*.iopin !
*.iopin pad[9],pad[8],pad[7],pad[6],pad[5],pad[4],pad[3],pad[2],pad[1],pad[0]
*.iopin sub
XM1 pad[0] net1 ! ! sg13_hv_pmos w=26.64u l=0.6u ng=4
XM2 pad[1] net1 ! ! sg13_hv_pmos w=26.64u l=0.6u ng=4
XM3 pad[2] net1 ! ! sg13_hv_pmos w=26.64u l=0.6u ng=4
XM4 pad[3] net1 ! ! sg13_hv_pmos w=26.64u l=0.6u ng=4
XM5 pad[4] net1 ! ! sg13_hv_pmos w=26.64u l=0.6u ng=4
XM6 pad[5] net1 ! ! sg13_hv_pmos w=26.64u l=0.6u ng=4
XM7 pad[6] net1 ! ! sg13_hv_pmos w=26.64u l=0.6u ng=4
XM8 pad[7] net1 ! ! sg13_hv_pmos w=26.64u l=0.6u ng=4
XM9 pad[8] net1 ! ! sg13_hv_pmos w=26.64u l=0.6u ng=4
XM10 pad[9] net1 ! ! sg13_hv_pmos w=26.64u l=0.6u ng=4
XR1 ! net1 sub! rppd w=0.5e-6 l=12.9e-6 m=1 b=0
.ends

* expanding   symbol:  sg13g2_Clamp_N20N0D.sym # of pins=3
** sym_path: /foss/designs/Design/UNICASS/unic-cass-analog-team3/designs/openpdk-libraries/ihp-sg13g2/sg13g2_io/xschem/sg13g2_Clamp_N20N0D.sym
** sch_path: /foss/designs/Design/UNICASS/unic-cass-analog-team3/designs/openpdk-libraries/ihp-sg13g2/sg13g2_io/xschem/sg13g2_Clamp_N20N0D.sch
.subckt sg13g2_Clamp_N20N0D iovss pad[9] pad[8] pad[7] pad[6] pad[5] pad[4] pad[3] pad[2] pad[1] pad[0] !
*.iopin iovss
*.iopin pad[9],pad[8],pad[7],pad[6],pad[5],pad[4],pad[3],pad[2],pad[1],pad[0]
*.iopin !
XR1 iovss ! ptap1 R=11.44 w=7.47e-6 l=7.47e-6
XM1 pad[0] net1 iovss ! sg13_hv_nmos w=8.8u l=0.6u ng=2
XM2 pad[1] net1 iovss ! sg13_hv_nmos w=8.8u l=0.6u ng=2
XM3 pad[2] net1 iovss ! sg13_hv_nmos w=8.8u l=0.6u ng=2
XM4 pad[3] net1 iovss ! sg13_hv_nmos w=8.8u l=0.6u ng=2
XM5 pad[4] net1 iovss ! sg13_hv_nmos w=8.8u l=0.6u ng=2
XM6 pad[5] net1 iovss ! sg13_hv_nmos w=8.8u l=0.6u ng=2
XM7 pad[6] net1 iovss ! sg13_hv_nmos w=8.8u l=0.6u ng=2
XM8 pad[7] net1 iovss ! sg13_hv_nmos w=8.8u l=0.6u ng=2
XM9 pad[8] net1 iovss ! sg13_hv_nmos w=8.8u l=0.6u ng=2
XM10 pad[9] net1 iovss ! sg13_hv_nmos w=8.8u l=0.6u ng=2
XR3 net1 iovss sub! rppd w=0.5e-6 l=3.54e-6 m=1 b=0
.ends

* expanding   symbol:  sg13g2_SecondaryProtection.sym # of pins=5
** sym_path: /foss/designs/Design/UNICASS/unic-cass-analog-team3/designs/openpdk-libraries/ihp-sg13g2/sg13g2_io/xschem/sg13g2_SecondaryProtection.sym
** sch_path: /foss/designs/Design/UNICASS/unic-cass-analog-team3/designs/openpdk-libraries/ihp-sg13g2/sg13g2_io/xschem/sg13g2_SecondaryProtection.sch
.subckt sg13g2_SecondaryProtection core iovdd iovss pad !
*.iopin iovss
*.iopin core
*.iopin pad
*.iopin iovdd
*.iopin !
XR1 iovss ! ptap1 R=46.56 w=3.005e-6 l=3.005e-6
XD1 core iovdd dpantenna l=4.98u w=0.64u
XD2 ! core dantenna l=3.1u w=0.64u
XR3 pad core sub! rppd w=1e-6 l=2e-6 m=1 b=0
.ends

* expanding   symbol:  sg13g2_GateLevelUpInv_noptap.sym # of pins=7
** sym_path: /foss/designs/Design/UNICASS/unic-cass-analog-team3/designs/openpdk-libraries/ihp-sg13g2/sg13g2_io/xschem/sg13g2_GateLevelUpInv_noptap.sym
** sch_path: /foss/designs/Design/UNICASS/unic-cass-analog-team3/designs/openpdk-libraries/ihp-sg13g2/sg13g2_io/xschem/sg13g2_GateLevelUpInv_noptap.sch
.subckt sg13g2_GateLevelUpInv_noptap iovdd vss core pgate vdd sub ngate
*.iopin iovdd
*.iopin vss
*.iopin pgate
*.iopin core
*.iopin vdd
*.iopin sub
*.iopin ngate
x1 iovdd vss core pgate vdd sub sg13g2_LevelUpInv_noptap
x2 iovdd vss core ngate vdd sub sg13g2_LevelUpInv_noptap
.ends

* expanding   symbol:  sg13g2_Clamp_N2N2D.sym # of pins=4
** sym_path: /foss/designs/Design/UNICASS/unic-cass-analog-team3/designs/openpdk-libraries/ihp-sg13g2/sg13g2_io/xschem/sg13g2_Clamp_N2N2D.sym
** sch_path: /foss/designs/Design/UNICASS/unic-cass-analog-team3/designs/openpdk-libraries/ihp-sg13g2/sg13g2_io/xschem/sg13g2_Clamp_N2N2D.sch
.subckt sg13g2_Clamp_N2N2D gate pad iovss sub
*.iopin iovss
*.iopin gate
*.iopin pad
*.iopin sub
XR1 iovss sub ptap1 R=11.44 w=7.47e-6 l=7.47e-6
XD1 sub gate dantenna l=0.78u w=0.78u
XM1 pad gate iovss sub sg13_hv_nmos w=4.4u l=0.6u ng=1
XM2 iovss gate pad sub sg13_hv_nmos w=4.4u l=0.6u ng=1
.ends

* expanding   symbol:  sg13g2_Clamp_P2N2D_noptap.sym # of pins=5
** sym_path: /foss/designs/Design/UNICASS/unic-cass-analog-team3/designs/openpdk-libraries/ihp-sg13g2/sg13g2_io/xschem/sg13g2_Clamp_P2N2D_noptap.sym
** sch_path: /foss/designs/Design/UNICASS/unic-cass-analog-team3/designs/openpdk-libraries/ihp-sg13g2/sg13g2_io/xschem/sg13g2_Clamp_P2N2D_noptap.sch
.subckt sg13g2_Clamp_P2N2D_noptap gate iovdd iovss pad sub
*.iopin iovss
*.iopin gate
*.iopin pad
*.iopin iovdd
*.iopin sub
XM1 pad gate iovdd iovdd sg13_hv_pmos w=13.32u l=0.6u ng=2
XM2 iovdd gate pad iovdd sg13_hv_pmos w=13.32u l=0.6u ng=2
XD1 gate iovdd dpantenna l=0.48u w=0.48u
.ends

* expanding   symbol:  NOR.sym # of pins=5
** sym_path: /foss/designs/Design/UNICASS/unic-cass-analog-team3/designs/libs/IHP__MPC0349/dependencies/IHP__OSC3593/OSC3593-main/schematic/xschem/NOR.sym
** sch_path: /foss/designs/Design/UNICASS/unic-cass-analog-team3/designs/libs/IHP__MPC0349/dependencies/IHP__OSC3593/OSC3593-main/schematic/xschem/NOR.sch
.subckt NOR VDD B A Y VSS
*.opin Y
*.ipin A
*.iopin VDD
*.iopin VSS
*.ipin B
XMN0 Y A VSS VSS sg13_lv_nmos w=740.00n l=130.00n ng=1
XMP0 net1 B VDD VDD sg13_lv_pmos w=1.12u l=130.00n ng=1
XMP1 Y A net1 VDD sg13_lv_pmos w=1.12u l=130.00n ng=1
XMN1 Y B VSS VSS sg13_lv_nmos w=740.00n l=130.00n ng=1
.ends

* expanding   symbol:  NAND.sym # of pins=5
** sym_path: /foss/designs/Design/UNICASS/unic-cass-analog-team3/designs/libs/IHP__MPC0349/dependencies/IHP__OSC3593/OSC3593-main/schematic/xschem/NAND.sym
** sch_path: /foss/designs/Design/UNICASS/unic-cass-analog-team3/designs/libs/IHP__MPC0349/dependencies/IHP__OSC3593/OSC3593-main/schematic/xschem/NAND.sch
.subckt NAND VDD B A Y VSS
*.opin Y
*.ipin A
*.iopin VDD
*.iopin VSS
*.ipin B
XMN0 Y A net1 VSS sg13_lv_nmos w=740.00n l=130.00n ng=1
XMP0 Y A VDD VDD sg13_lv_pmos w=1.12u l=130.00n ng=1
XMP1 Y B VDD VDD sg13_lv_pmos w=1.12u l=130.00n ng=1
XMN1 net1 B VSS VSS sg13_lv_nmos w=740.00n l=130.00n ng=1
.ends

* expanding   symbol:  OTA_Telescopic_currentRef.sym # of pins=6
** sym_path: /foss/designs/Design/UNICASS/unic-cass-analog-team3/designs/libs/IHP__MPC0349/dependencies/IHP__OPA2251/OPA2251-main/schematic/xschem/OTA_Telescopic_currentRef.sym
** sch_path: /foss/designs/Design/UNICASS/unic-cass-analog-team3/designs/libs/IHP__MPC0349/dependencies/IHP__OPA2251/OPA2251-main/schematic/xschem/OTA_Telescopic_currentRef.sch
.subckt OTA_Telescopic_currentRef VDD I_P I_N VSS I_P2 I_P3
*.iopin VDD
*.iopin VSS
*.iopin I_P
*.iopin I_N
*.iopin I_P2
*.iopin I_P3
XM3 net2 net2 VDD VDD sg13_lv_pmos w=12u l=2.5u ng=2
XM2 net2 net1 net3 VSS sg13_lv_nmos w=12u l=6.4u ng=2 m=8
XM4 net1 net2 VDD VDD sg13_lv_pmos w=12u l=2.5u ng=2
XM1 net1 net1 VSS VSS sg13_lv_nmos w=12u l=6.4u ng=2
XM5 net2 net2 net1 VSS sg13_lv_nmos w=2u l=1u ng=1
XR2 net3 VSS VSS rppd w=1e-6 l=11.5e-6 m=1 b=0
XM6 I_P net2 VDD VDD sg13_lv_pmos w=12u l=2.5u ng=2
XM7 I_N net1 VSS VSS sg13_lv_nmos w=12u l=6.4u ng=2
XM8 I_P2 net2 VDD VDD sg13_lv_pmos w=12u l=2.5u ng=2
XM9 I_P3 net2 VDD VDD sg13_lv_pmos w=12u l=2.5u ng=2
.ends

* expanding   symbol:  OTA_Telescopic_CMFB.sym # of pins=7
** sym_path: /foss/designs/Design/UNICASS/unic-cass-analog-team3/designs/libs/IHP__MPC0349/dependencies/IHP__OPA2251/OPA2251-main/schematic/xschem/OTA_Telescopic_CMFB.sym
** sch_path: /foss/designs/Design/UNICASS/unic-cass-analog-team3/designs/libs/IHP__MPC0349/dependencies/IHP__OPA2251/OPA2251-main/schematic/xschem/OTA_Telescopic_CMFB.sch
.subckt OTA_Telescopic_CMFB VDD VREF VINN VINP IBIAS CMFB VSS
*.iopin VDD
*.iopin VSS
*.opin CMFB
*.ipin VREF
*.iopin IBIAS
*.ipin VINP
*.ipin VINN
XM0 IBIAS IBIAS VDD VDD sg13_lv_pmos w=6u l=0.7u ng=6 m=8
XM1 V1 IBIAS VDD VDD sg13_lv_pmos w=6u l=0.7u ng=6 m=24
XM2 V2 IBIAS VDD VDD sg13_lv_pmos w=6u l=0.7u ng=6 m=24
XM3 CMFB VINP V1 VDD sg13_lv_pmos w=8.995u l=0.35u ng=7 m=4
XM4 net1 VREF V1 VDD sg13_lv_pmos w=8.995u l=0.35u ng=7 m=4
XM5 net1 VREF V2 VDD sg13_lv_pmos w=8.995u l=0.35u ng=7 m=4
XM6 CMFB VINN V2 VDD sg13_lv_pmos w=8.995u l=0.35u ng=7 m=4
XM7 net1 net1 VSS VSS sg13_lv_nmos w=29.97u l=0.20u ng=9
XM8 CMFB CMFB VSS VSS sg13_lv_nmos w=29.97u l=0.20u ng=9
.ends

* expanding   symbol:  OTA_Telescopic_FB.sym # of pins=12
** sym_path: /foss/designs/Design/UNICASS/unic-cass-analog-team3/designs/libs/IHP__MPC0349/dependencies/IHP__OPA2251/OPA2251-main/schematic/xschem/OTA_Telescopic_FB.sym
** sch_path: /foss/designs/Design/UNICASS/unic-cass-analog-team3/designs/libs/IHP__MPC0349/dependencies/IHP__OPA2251/OPA2251-main/schematic/xschem/OTA_Telescopic_FB.sch
.subckt OTA_Telescopic_FB IB VPout VP VPin VOUTP VDD VOUTN VSS VNin VNout VN CMFBin
*.ipin VP
*.ipin VN
*.opin VOUTP
*.opin VOUTN
*.ipin VPin
*.ipin VNin
*.opin VPout
*.opin VNout
*.iopin VDD
*.iopin VSS
*.ipin CMFBin
*.ipin IB
x1 VDD CMFBin VOUTN VOUTP VPin VNin VSS IB OTA_Telescopic_core
XR3 VNout VN VSS rppd w=0.6e-6 l=6.73e-6 m=1 b=0
XR4 VP VPout VSS rppd w=0.6e-6 l=6.73e-6 m=1 b=0
XR5 VPout VOUTP VSS rppd w=0.6e-6 l=19e-6 m=1 b=0
XR2 VNout VOUTN VSS rppd w=0.6e-6 l=19e-6 m=1 b=0
.ends

* expanding   symbol:  Buffer.sym # of pins=5
** sym_path: /foss/designs/Design/UNICASS/unic-cass-analog-team3/designs/libs/IHP__MPC0349/dependencies/IHP__OPA2251/OPA2251-main/schematic/xschem/Buffer.sym
** sch_path: /foss/designs/Design/UNICASS/unic-cass-analog-team3/designs/libs/IHP__MPC0349/dependencies/IHP__OPA2251/OPA2251-main/schematic/xschem/Buffer.sch
.subckt Buffer VDD VOUT IB VIN VSS
*.iopin VDD
*.iopin VSS
*.ipin VIN
*.opin VOUT
*.ipin IB
XM5 net1 IB VSS VSS sg13_lv_nmos w=3u l=1u ng=1 m=3
XM6 IB IB VSS VSS sg13_lv_nmos w=3u l=1u ng=1
XM1 vm VIN net1 VSS sg13_lv_nmos w=10u l=0.5u ng=1 m=16
XM2 vota VOUT net1 VSS sg13_lv_nmos w=10u l=0.5u ng=1 m=16
XM3 vm vm VDD VDD sg13_lv_pmos w=10u l=1u ng=1 m=4
XM4 vota vm VDD VDD sg13_lv_pmos w=10u l=1u ng=1 m=4
XM7 VDD vota VOUT VSS sg13_lv_nmos w=10u l=0.15u ng=1 m=25
XM8 VOUT IB VSS VSS sg13_lv_nmos w=3u l=1u ng=1
.ends

* expanding   symbol:  integrator.sym # of pins=6
** sym_path: /foss/designs/Design/UNICASS/unic-cass-analog-team3/designs/libs/IHP__MPC0349/dependencies/IHP__OSC9996/OSC9996-main/schematic/xschem/integrator.sym
** sch_path: /foss/designs/Design/UNICASS/unic-cass-analog-team3/designs/libs/IHP__MPC0349/dependencies/IHP__OSC9996/OSC9996-main/schematic/xschem/integrator.sch
.subckt integrator Vref VSS VDD RST Vctr VOUT
*.ipin VSS
*.ipin Vref
*.ipin Vctr
*.ipin VDD
*.ipin RST
*.opin VOUT
xIP0 VDD VctrPP P0 P1 Vctr VSS RST integrator_curstav_inv
xIP1 VDD VctrPP P1 P2 Vctr VSS VSS integrator_curstav_inv
xIP2 VDD VctrPP P2 P3 Vctr VSS RST integrator_curstav_inv
xIP3 VDD VctrPP P3 P4 Vctr VSS VSS integrator_curstav_inv
xIP4 VDD VctrPP P4 P0 Vctr VSS RST integrator_curstav_inv
xPD0 VDD R1 VOUT P1 VSS integrator_phasedetector
xPD1 VDD R2 VOUT P2 VSS integrator_phasedetector
xPD2 VDD R3 VOUT P3 VSS integrator_phasedetector
xPD3 VDD R4 VOUT P4 VSS integrator_phasedetector
xPD4 VDD R0 VOUT P0 VSS integrator_phasedetector
XM1 VctrPP Vctr VSS VSS sg13_lv_nmos w=1.0u l=0.13u ng=1
XM3 VctrPP VctrPP VDD VDD sg13_lv_pmos w=2u l=0.13u ng=1
XM2 VctrPR VctrPR VDD VDD sg13_lv_pmos w=2u l=0.13u ng=1
XM4 VctrPR Vref VSS VSS sg13_lv_nmos w=1.0u l=0.13u ng=1
xIR0 VDD VctrPR R0 R1 Vref VSS RST integrator_curstav_inv
xIR1 VDD VctrPR R1 R2 Vref VSS VSS integrator_curstav_inv
xIR2 VDD VctrPR R2 R3 Vref VSS RST integrator_curstav_inv
xIR3 VDD VctrPR R3 R4 Vref VSS VSS integrator_curstav_inv
xIR4 VDD VctrPR R4 R0 Vref VSS RST integrator_curstav_inv
.ends

* expanding   symbol:  spike_generator.sym # of pins=6
** sym_path: /foss/designs/Design/UNICASS/unic-cass-analog-team3/designs/libs/IHP__MPC0349/dependencies/IHP__OSC9996/OSC9996-main/schematic/xschem/spike_generator.sym
** sch_path: /foss/designs/Design/UNICASS/unic-cass-analog-team3/designs/libs/IHP__MPC0349/dependencies/IHP__OSC9996/OSC9996-main/schematic/xschem/spike_generator.sch
.subckt spike_generator VDD Vcmp Vspk Vrst Ven VSS
*.iopin Vcmp
*.iopin Ven
*.iopin Vrst
*.iopin Vspk
*.iopin VDD
*.iopin VSS
xEDGE Vcmp SPK_OUT VDD VSS edge_detector
xBSPK VDD SPK_OUT Vspk VSS gate_buff_L0d13
xBRST VDD net1 Vrst VSS gate_buff_L0d13
xOR Ven VDD VSS net1 Vcmp gate_or
.ends

* expanding   symbol:  resistence_bank.sym # of pins=3
** sym_path: /foss/designs/Design/UNICASS/unic-cass-analog-team3/designs/libs/IHP__MPC0349/dependencies/IHP__OSC9996/OSC9996-main/schematic/xschem/resistence_bank.sym
** sch_path: /foss/designs/Design/UNICASS/unic-cass-analog-team3/designs/libs/IHP__MPC0349/dependencies/IHP__OSC9996/OSC9996-main/schematic/xschem/resistence_bank.sch
.subckt resistence_bank VDD MEM Vx
*.iopin VDD
*.iopin Vx
*.iopin MEM
XRFB0 Vx net4 sub! rhigh w=0.5e-6 l=4e-6 m=1 b=0
XRFB1 net4 net3 sub! rhigh w=0.5e-6 l=4e-6 m=1 b=0
XRFB2 net3 net2 sub! rhigh w=0.5e-6 l=4e-6 m=1 b=0
XRFB3 net2 net1 sub! rhigh w=0.5e-6 l=4e-6 m=1 b=0
XRDMY1[7] VDD VDD sub! rhigh w=0.5e-6 l=4e-6 m=1 b=0
XRDMY1[6] VDD VDD sub! rhigh w=0.5e-6 l=4e-6 m=1 b=0
XRDMY1[5] VDD VDD sub! rhigh w=0.5e-6 l=4e-6 m=1 b=0
XRDMY1[4] VDD VDD sub! rhigh w=0.5e-6 l=4e-6 m=1 b=0
XRDMY1[3] VDD VDD sub! rhigh w=0.5e-6 l=4e-6 m=1 b=0
XRDMY1[2] VDD VDD sub! rhigh w=0.5e-6 l=4e-6 m=1 b=0
XRDMY1[1] VDD VDD sub! rhigh w=0.5e-6 l=4e-6 m=1 b=0
XRDMY1[0] VDD VDD sub! rhigh w=0.5e-6 l=4e-6 m=1 b=0
XRFB6 net1 net5 sub! rhigh w=0.5e-6 l=4e-6 m=1 b=0
XRFB7 net5 net6 sub! rhigh w=0.5e-6 l=4e-6 m=1 b=0
XRFB8 net6 net7 sub! rhigh w=0.5e-6 l=4e-6 m=1 b=0
XRFB9 net7 MEM sub! rhigh w=0.5e-6 l=4e-6 m=1 b=0
XRDMY2[7] VDD VDD sub! rhigh w=0.5e-6 l=0.96e-6 m=1 b=0
XRDMY2[6] VDD VDD sub! rhigh w=0.5e-6 l=0.96e-6 m=1 b=0
XRDMY2[5] VDD VDD sub! rhigh w=0.5e-6 l=0.96e-6 m=1 b=0
XRDMY2[4] VDD VDD sub! rhigh w=0.5e-6 l=0.96e-6 m=1 b=0
XRDMY2[3] VDD VDD sub! rhigh w=0.5e-6 l=0.96e-6 m=1 b=0
XRDMY2[2] VDD VDD sub! rhigh w=0.5e-6 l=0.96e-6 m=1 b=0
XRDMY2[1] VDD VDD sub! rhigh w=0.5e-6 l=0.96e-6 m=1 b=0
XRDMY2[0] VDD VDD sub! rhigh w=0.5e-6 l=0.96e-6 m=1 b=0
.ends

* expanding   symbol:  threshold_comparator.sym # of pins=4
** sym_path: /foss/designs/Design/UNICASS/unic-cass-analog-team3/designs/libs/IHP__MPC0349/dependencies/IHP__OSC9996/OSC9996-main/schematic/xschem/threshold_comparator.sym
** sch_path: /foss/designs/Design/UNICASS/unic-cass-analog-team3/designs/libs/IHP__MPC0349/dependencies/IHP__OSC9996/OSC9996-main/schematic/xschem/threshold_comparator.sch
.subckt threshold_comparator VDD Vin Vout VSS
*.iopin VDD
*.iopin VSS
*.ipin Vin
*.opin Vout
XM2 Vx Vin VDD VDD sg13_lv_pmos w=2u l=0.13u ng=1 m=2
XM1 Vx Vin VSS VSS sg13_lv_nmos w=1.0u l=0.13u ng=1 m=2
XM3 Vout Vx VDD VDD sg13_lv_pmos w=2u l=0.13u ng=1 m=2
XM4 Vout Vx VSS VSS sg13_lv_nmos w=1.0u l=0.13u ng=1 m=2
.ends

* expanding   symbol:  flipflopn.sym # of pins=6
** sym_path: /foss/designs/Design/UNICASS/unic-cass-analog-team3/designs/libs/IHP__MPC0349/dependencies/IHP__OSC3593/OSC3593-main/schematic/xschem/flipflopn.sym
** sch_path: /foss/designs/Design/UNICASS/unic-cass-analog-team3/designs/libs/IHP__MPC0349/dependencies/IHP__OSC3593/OSC3593-main/schematic/xschem/flipflopn.sch
.subckt flipflopn CLK Q_n VDD Q D VSS
*.ipin D
*.opin Q
*.iopin CLK
*.iopin VDD
*.iopin VSS
*.opin Q_n
XMN0 net1 net7 net2 VSS sg13_lv_nmos w=740.00n l=130.00n ng=1
XMP0 net1 CLK net2 VDD sg13_lv_pmos w=1.12u l=130.00n ng=1
XMN1 net2 CLK net3 VSS sg13_lv_nmos w=740.00n l=130.00n ng=1
XMP1 net2 net7 net3 VDD sg13_lv_pmos w=1.12u l=130.00n ng=1
*  x2 -  inv  IS MISSING !!!!
*  x3 -  inv  IS MISSING !!!!
*  x4 -  inv  IS MISSING !!!!
XMN2 net4 CLK net5 VSS sg13_lv_nmos w=740.00n l=130.00n ng=1
XMP2 net4 net7 net5 VDD sg13_lv_pmos w=1.12u l=130.00n ng=1
XMN3 net5 net7 net6 VSS sg13_lv_nmos w=740.00n l=130.00n ng=1
XMP3 net5 CLK net6 VDD sg13_lv_pmos w=1.12u l=130.00n ng=1
*  x5 -  inv  IS MISSING !!!!
*  x6 -  inv  IS MISSING !!!!
*  x8 -  inv  IS MISSING !!!!
*  x9 -  inv  IS MISSING !!!!
.ends

* expanding   symbol:  AND3.sym # of pins=6
** sym_path: /foss/designs/Design/UNICASS/unic-cass-analog-team3/designs/libs/IHP__MPC0349/dependencies/IHP__OSC3593/OSC3593-main/schematic/xschem/AND3.sym
** sch_path: /foss/designs/Design/UNICASS/unic-cass-analog-team3/designs/libs/IHP__MPC0349/dependencies/IHP__OSC3593/OSC3593-main/schematic/xschem/AND3.sch
.subckt AND3 VDD A B C Y VSS
*.ipin A
*.iopin VDD
*.iopin VSS
*.ipin B
*.ipin C
*.opin Y
XMN0 net1 B net2 VSS sg13_lv_nmos w=740.00n l=130.00n ng=1
XMP0 net3 A VDD VDD sg13_lv_pmos w=1.12u l=130.00n ng=1
XMN1 net3 A net1 VSS sg13_lv_nmos w=740.00n l=130.00n ng=1
XMN2 net2 C VSS VSS sg13_lv_nmos w=740.00n l=130.00n ng=1
XMP1 net3 B VDD VDD sg13_lv_pmos w=1.12u l=130.00n ng=1
XMP2 net3 C VDD VDD sg13_lv_pmos w=1.12u l=130.00n ng=1
XMN3 Y net3 VSS VSS sg13_lv_nmos w=740.00n l=130.00n ng=1
XMP3 Y net3 VDD VDD sg13_lv_pmos w=1.12u l=130.00n ng=1
.ends

* expanding   symbol:  sg13g2_SecondaryProtection_noptap.sym # of pins=5
** sym_path: /foss/designs/Design/UNICASS/unic-cass-analog-team3/designs/openpdk-libraries/ihp-sg13g2/sg13g2_io/xschem/sg13g2_SecondaryProtection_noptap.sym
** sch_path: /foss/designs/Design/UNICASS/unic-cass-analog-team3/designs/openpdk-libraries/ihp-sg13g2/sg13g2_io/xschem/sg13g2_SecondaryProtection_noptap.sch
.subckt sg13g2_SecondaryProtection_noptap core iovdd iovss pad !
*.iopin iovss
*.iopin core
*.iopin pad
*.iopin iovdd
*.iopin !
XD1 core iovdd dpantenna l=4.98u w=0.64u
XD2 ! core dantenna l=3.1u w=0.64u
XR1 core pad sub! rppd w=1e-6 l=2e-6 m=1 b=0
.ends

* expanding   symbol:  sg13g2_LevelUpInv_noptap.sym # of pins=6
** sym_path: /foss/designs/Design/UNICASS/unic-cass-analog-team3/designs/openpdk-libraries/ihp-sg13g2/sg13g2_io/xschem/sg13g2_LevelUpInv_noptap.sym
** sch_path: /foss/designs/Design/UNICASS/unic-cass-analog-team3/designs/openpdk-libraries/ihp-sg13g2/sg13g2_io/xschem/sg13g2_LevelUpInv_noptap.sch
.subckt sg13g2_LevelUpInv_noptap iovdd vss in out vdd sub
*.iopin iovdd
*.iopin vss
*.iopin out
*.iopin in
*.iopin vdd
*.iopin sub
XM1 net1 in vss sub sg13_hv_nmos w=1.9u l=0.45u ng=1
XM3 net1 net2 iovdd iovdd sg13_hv_pmos w=0.3u l=0.45u ng=1
XM4 net2 net1 iovdd iovdd sg13_hv_pmos w=0.3u l=0.45u ng=1
XM5 out net2 iovdd iovdd sg13_hv_pmos w=3.9u l=0.45u ng=1
XM2 net2 net3 vss sub sg13_hv_nmos w=1.9u l=0.45u ng=1
XM6 out net2 vss sub sg13_hv_nmos w=1.9u l=0.45u ng=1
XM7 net3 in vss sub sg13_lv_nmos w=2.75u l=0.13u ng=1
XM8 net3 in vdd vdd sg13_lv_pmos w=4.75u l=0.13u ng=1
.ends

* expanding   symbol:  OTA_Telescopic_core.sym # of pins=8
** sym_path: /foss/designs/Design/UNICASS/unic-cass-analog-team3/designs/libs/IHP__MPC0349/dependencies/IHP__OPA2251/OPA2251-main/schematic/xschem/OTA_Telescopic_core.sym
** sch_path: /foss/designs/Design/UNICASS/unic-cass-analog-team3/designs/libs/IHP__MPC0349/dependencies/IHP__OPA2251/OPA2251-main/schematic/xschem/OTA_Telescopic_core.sch
.subckt OTA_Telescopic_core VDD CMFB VOUTP VOUTN VINP VINN VSS IB
*.iopin VDD
*.iopin VSS
*.ipin VINP
*.ipin VINN
*.opin VOUTN
*.opin VOUTP
*.ipin CMFB
*.iopin IB
XM15 VB55 VB55 VDD VDD sg13_lv_pmos w=1.4u l=0.35u ng=1 m=8
XM17 VB33 VB33 VDD VDD sg13_lv_pmos w=2.05u l=0.35u ng=1
XM18 VB22 VB33 VDD VDD sg13_lv_pmos w=2.05u l=0.35u ng=1
XM9 VOUTP Vo1 VDD VDD sg13_lv_pmos w=1.37u l=0.35u ng=1 m=250
XM7 Vx1 VB55 VDD VDD sg13_lv_pmos w=7u l=0.7u ng=1 m=30
XM5 Vo1 VB33 Vx1 VDD sg13_lv_pmos w=4.05u l=0.5u ng=1 m=30
XM8 Vx2 VB55 VDD VDD sg13_lv_pmos w=7u l=0.7u ng=1 m=30
XM6 Vo2 VB33 Vx2 VDD sg13_lv_pmos w=4.05u l=0.5u ng=1 m=30
XM10 VOUTN Vo2 VDD VDD sg13_lv_pmos w=1.37u l=0.35u ng=1 m=250
XM13 IB IB VSS VSS sg13_lv_nmos w=4.8u l=1.06u ng=1
XM14 VB55 IB VSS VSS sg13_lv_nmos w=4.8u l=1.06u ng=1
XM16 VB33 IB VSS VSS sg13_lv_nmos w=4.8u l=1.06u ng=1
XM19 VB22 VB22 VSS VSS sg13_lv_nmos w=0.5u l=0.8u ng=1
XM11 VOUTP IB VSS VSS sg13_lv_nmos w=4.8u l=1.06u ng=1 m=55
XM0 P CMFB VSS VSS sg13_lv_nmos w=29.97u l=0.20u ng=9 m=6
XM3 Vo1 VB22 Vy1 VSS sg13_lv_nmos w=1.9u l=0.16u ng=1 m=30
XM1 Vy1 VINP P VSS sg13_lv_nmos w=1.1u l=0.15u ng=1 m=30
XM4 Vo2 VB22 Vy2 VSS sg13_lv_nmos w=1.9u l=0.16u ng=1 m=30
XM2 Vy2 VINN P VSS sg13_lv_nmos w=1.1u l=0.15u ng=1 m=30
XM12 VOUTN IB VSS VSS sg13_lv_nmos w=4.8u l=1.06u ng=1 m=55
XR3 Vo1 net1 VSS rppd w=1.5e-6 l=0.55e-6 m=1 b=0
XR1 net2 Vo2 VSS rppd w=1.5e-6 l=0.55e-6 m=1 b=0
XC3 net2 VOUTN cap_cmim w=21.4e-6 l=21.4e-6
XC1 net1 VOUTP cap_cmim w=21.4e-6 l=21.4e-6
.ends

* expanding   symbol:  integrator_curstav_inv.sym # of pins=7
** sym_path: /foss/designs/Design/UNICASS/unic-cass-analog-team3/designs/libs/IHP__MPC0349/dependencies/IHP__OSC9996/OSC9996-main/schematic/xschem/integrator_curstav_inv.sym
** sch_path: /foss/designs/Design/UNICASS/unic-cass-analog-team3/designs/libs/IHP__MPC0349/dependencies/IHP__OSC9996/OSC9996-main/schematic/xschem/integrator_curstav_inv.sch
.subckt integrator_curstav_inv VDD VcrtP A B VcrtN VSS RST
*.ipin VDD
*.ipin VSS
*.ipin A
*.opin B
*.ipin VcrtP
*.ipin VcrtN
*.ipin RST
XM1 B A net2 VSS sg13_lv_nmos w=1.0u l=0.13u ng=1
XM2 net2 VcrtN VSS VSS sg13_lv_nmos w=1.0u l=0.13u ng=1
XM3 B A net1 VDD sg13_lv_pmos w=2u l=0.13u ng=1
XM4 net1 VcrtP VDD VDD sg13_lv_pmos w=2u l=0.13u ng=1
XM5 B VDD VDD VDD sg13_lv_pmos w=2u l=0.13u ng=1
XM6 B RST VSS VSS sg13_lv_nmos w=1.0u l=0.13u ng=1
.ends

* expanding   symbol:  integrator_phasedetector.sym # of pins=5
** sym_path: /foss/designs/Design/UNICASS/unic-cass-analog-team3/designs/libs/IHP__MPC0349/dependencies/IHP__OSC9996/OSC9996-main/schematic/xschem/integrator_phasedetector.sym
** sch_path: /foss/designs/Design/UNICASS/unic-cass-analog-team3/designs/libs/IHP__MPC0349/dependencies/IHP__OSC9996/OSC9996-main/schematic/xschem/integrator_phasedetector.sch
.subckt integrator_phasedetector VDD A VOUT B VSS
*.ipin A
*.ipin B
*.ipin VSS
*.ipin VDD
*.opin VOUT
x1 VDD XOR B A VSS gate_xor
x2 VDD XOR BUF VSS gate_buff_L0d13
XRXOR[1] BUF VOUT sub! rppd w=0.5e-6 l=0.5e-6 m=1 b=0
XRXOR[0] BUF VOUT sub! rppd w=0.5e-6 l=0.5e-6 m=1 b=0
XRDMY[9] VSS VSS sub! rppd w=0.5e-6 l=0.5e-6 m=1 b=0
XRDMY[8] VSS VSS sub! rppd w=0.5e-6 l=0.5e-6 m=1 b=0
XRDMY[7] VSS VSS sub! rppd w=0.5e-6 l=0.5e-6 m=1 b=0
XRDMY[6] VSS VSS sub! rppd w=0.5e-6 l=0.5e-6 m=1 b=0
XRDMY[5] VSS VSS sub! rppd w=0.5e-6 l=0.5e-6 m=1 b=0
XRDMY[4] VSS VSS sub! rppd w=0.5e-6 l=0.5e-6 m=1 b=0
XRDMY[3] VSS VSS sub! rppd w=0.5e-6 l=0.5e-6 m=1 b=0
XRDMY[2] VSS VSS sub! rppd w=0.5e-6 l=0.5e-6 m=1 b=0
XRDMY[1] VSS VSS sub! rppd w=0.5e-6 l=0.5e-6 m=1 b=0
XRDMY[0] VSS VSS sub! rppd w=0.5e-6 l=0.5e-6 m=1 b=0
.ends

* expanding   symbol:  edge_detector.sym # of pins=4
** sym_path: /foss/designs/Design/UNICASS/unic-cass-analog-team3/designs/libs/IHP__MPC0349/dependencies/IHP__OSC9996/OSC9996-main/schematic/xschem/edge_detector.sym
** sch_path: /foss/designs/Design/UNICASS/unic-cass-analog-team3/designs/libs/IHP__MPC0349/dependencies/IHP__OSC9996/OSC9996-main/schematic/xschem/edge_detector.sch
.subckt edge_detector IN OUT VDD VSS
*.iopin VDD
*.iopin VSS
*.ipin IN
*.opin OUT
xAND IN VDD VSS OUT I4 gate_and
xINV0 VDD I0 IN VSS gate_inv_L0d65
xINV1 VDD I1 I0 VSS gate_inv_L0d65
xINV2 VDD I2 I1 VSS gate_inv_L0d65
xINV3 VDD I3 I2 VSS gate_inv_L0d65
xINV4 VDD I4 I3 VSS gate_inv_L0d65
.ends

* expanding   symbol:  gate_buff_L0d13.sym # of pins=4
** sym_path: /foss/designs/Design/UNICASS/unic-cass-analog-team3/designs/libs/IHP__MPC0349/dependencies/IHP__OSC9996/OSC9996-main/schematic/xschem/gate_buff_L0d13.sym
** sch_path: /foss/designs/Design/UNICASS/unic-cass-analog-team3/designs/libs/IHP__MPC0349/dependencies/IHP__OSC9996/OSC9996-main/schematic/xschem/gate_buff_L0d13.sch
.subckt gate_buff_L0d13 VDD VIN VOUT VSS
*.ipin VDD
*.ipin VIN
*.ipin VSS
*.opin VOUT
XM1 net1 VIN VSS VSS sg13_lv_nmos w=1.0u l=0.13u ng=1
XM2 net1 VIN VDD VDD sg13_lv_pmos w=2u l=0.13u ng=1
XM3 VOUT net1 VSS VSS sg13_lv_nmos w=1.0u l=0.13u ng=1 m=3
XM4 VOUT net1 VDD VDD sg13_lv_pmos w=2u l=0.13u ng=1 m=3
.ends

* expanding   symbol:  gate_or.sym # of pins=5
** sym_path: /foss/designs/Design/UNICASS/unic-cass-analog-team3/designs/libs/IHP__MPC0349/dependencies/IHP__OSC9996/OSC9996-main/schematic/xschem/gate_or.sym
** sch_path: /foss/designs/Design/UNICASS/unic-cass-analog-team3/designs/libs/IHP__MPC0349/dependencies/IHP__OSC9996/OSC9996-main/schematic/xschem/gate_or.sch
.subckt gate_or B VDD VSS OUT A
*.opin OUT
*.ipin A
*.iopin VDD
*.iopin VSS
*.ipin B
XMNB OUTN B VSS VSS sg13_lv_nmos w=1.0u l=0.13u ng=1
XMNA OUTN A VSS VSS sg13_lv_nmos w=1.0u l=0.13u ng=1
XMPA X A VDD VDD sg13_lv_pmos w=2u l=0.13u ng=1
XMPB OUTN B X VDD sg13_lv_pmos w=2u l=0.13u ng=1
XMNI OUT OUTN VSS VSS sg13_lv_nmos w=1.0u l=0.13u ng=1
XMPI OUT OUTN VDD VDD sg13_lv_pmos w=2u l=0.13u ng=1
.ends

* expanding   symbol:  gate_xor.sym # of pins=5
** sym_path: /foss/designs/Design/UNICASS/unic-cass-analog-team3/designs/libs/IHP__MPC0349/dependencies/IHP__OSC9996/OSC9996-main/schematic/xschem/gate_xor.sym
** sch_path: /foss/designs/Design/UNICASS/unic-cass-analog-team3/designs/libs/IHP__MPC0349/dependencies/IHP__OSC9996/OSC9996-main/schematic/xschem/gate_xor.sch
.subckt gate_xor VDD S B A VSS
*.ipin VSS
*.ipin B
*.ipin A
*.ipin VDD
*.opin S
XM2 net1 A VDD VDD sg13_lv_pmos w=2u l=0.13u ng=1
XM1 S -B net1 VDD sg13_lv_pmos w=2u l=0.13u ng=1
XM4 net2 -A VDD VDD sg13_lv_pmos w=2u l=0.13u ng=1
XM5 S B net2 VDD sg13_lv_pmos w=2u l=0.13u ng=1
XM6 S B net4 VSS sg13_lv_nmos w=1.0u l=0.13u ng=1
XM3 net4 A VSS VSS sg13_lv_nmos w=1.0u l=0.13u ng=1
XM7 S -B net3 VSS sg13_lv_nmos w=1.0u l=0.13u ng=1
XM8 net3 -A VSS VSS sg13_lv_nmos w=1.0u l=0.13u ng=1
x3 VDD A -A VSS gate_inv_L0d13
x1 VDD B -B VSS gate_inv_L0d13
.ends

* expanding   symbol:  gate_and.sym # of pins=5
** sym_path: /foss/designs/Design/UNICASS/unic-cass-analog-team3/designs/libs/IHP__MPC0349/dependencies/IHP__OSC9996/OSC9996-main/schematic/xschem/gate_and.sym
** sch_path: /foss/designs/Design/UNICASS/unic-cass-analog-team3/designs/libs/IHP__MPC0349/dependencies/IHP__OSC9996/OSC9996-main/schematic/xschem/gate_and.sch
.subckt gate_and B VDD VSS OUT A
*.opin OUT
*.ipin A
*.iopin VDD
*.iopin VSS
*.ipin B
XMNB OUTN B NX VSS sg13_lv_nmos w=1u l=0.13u ng=1
XMNA NX A VSS VSS sg13_lv_nmos w=1u l=0.13u ng=1
XMPB OUTN B VDD VDD sg13_lv_pmos w=2u l=0.13u ng=1
XMPA OUTN A VDD VDD sg13_lv_pmos w=2u l=0.13u ng=1
XMNI OUT OUTN VSS VSS sg13_lv_nmos w=1u l=0.13u ng=1
XMPI OUT OUTN VDD VDD sg13_lv_pmos w=2u l=0.13u ng=1
.ends

* expanding   symbol:  gate_inv_L0d65.sym # of pins=4
** sym_path: /foss/designs/Design/UNICASS/unic-cass-analog-team3/designs/libs/IHP__MPC0349/dependencies/IHP__OSC9996/OSC9996-main/schematic/xschem/gate_inv_L0d65.sym
** sch_path: /foss/designs/Design/UNICASS/unic-cass-analog-team3/designs/libs/IHP__MPC0349/dependencies/IHP__OSC9996/OSC9996-main/schematic/xschem/gate_inv_L0d65.sch
.subckt gate_inv_L0d65 VDD B A VSS
*.opin B
*.ipin A
*.iopin VDD
*.iopin VSS
XMN B A VSS VSS sg13_lv_nmos w=1u l=0.65u ng=1
XMP B A VDD VDD sg13_lv_pmos w=2u l=0.65u ng=1
.ends

* expanding   symbol:  gate_inv_L0d13.sym # of pins=4
** sym_path: /foss/designs/Design/UNICASS/unic-cass-analog-team3/designs/libs/IHP__MPC0349/dependencies/IHP__OSC9996/OSC9996-main/schematic/xschem/gate_inv_L0d13.sym
** sch_path: /foss/designs/Design/UNICASS/unic-cass-analog-team3/designs/libs/IHP__MPC0349/dependencies/IHP__OSC9996/OSC9996-main/schematic/xschem/gate_inv_L0d13.sch
.subckt gate_inv_L0d13 VDD VIN VOUT VSS
*.ipin VDD
*.ipin VSS
*.ipin VIN
*.opin VOUT
XM2 VOUT VIN VDD VDD sg13_lv_pmos w=2u l=0.13u ng=1
XM1 VOUT VIN VSS VSS sg13_lv_nmos w=1.0u l=0.13u ng=1
.ends

.end
